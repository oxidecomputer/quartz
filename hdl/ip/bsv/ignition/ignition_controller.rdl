// Copyright 2022 Oxide Computer Company
//
// This Source Code Form is subject to the terms of the Mozilla Public
// License, v. 2.0. If a copy of the MPL was not distributed with this
// file, You can obtain one at https://mozilla.org/MPL/2.0/.

reg link_status {
    regwidth = 8;
    default sw = r;
    default hw = w;

    field {
        desc = "Flag indicating the receiver is aligned to the symbol boundaries";
    } RECEIVER_ALIGNED[1] = 0;
    field {
        desc = "Flag indicating the receiver is receiving valid ordered sets";
    } RECEIVER_LOCKED[1] = 0;
    field {
        desc = "Flag indicating the receiver detected the polarity of the link to be inverted";
    } RECEIVER_POLARITY_INVERTED[1] = 0;
};

reg link_events {
    regwidth = 8;
    default sw = rw;
    default hw = rw;

    field {
        desc = "Flag indicating the transmitter encountered an invalid value";
    } ENCODING_ERROR[1] = 0;
    field {
        desc = "Flag indicating the receiver encountered an invalid character";
    } DECODING_ERROR[1] = 0;
    field {
        desc = "Flag indicating an invalid ordered set was received";
    } ORDERED_SET_INVALID[1] = 0;
    field {
        desc = "Flag indicating a message with invalid version was received";
    } MESSAGE_VERSION_INVALID[1] = 0;
    field {
        desc = "Flag indicating a message with invalid type was received";
    } MESSAGE_TYPE_INVALID[1] = 0;
    field {
        desc = "Flag indicating a message with invalid checksum was received";
    } MESSAGE_CHECKSUM_INVALID[1] = 0;
};

reg counter {
    regwidth = 8;

    field {
        sw = r;
        hw = w;
        rclr;
    } COUNT[7:0] = 0;
};

addrmap ignition_controller {
    name = "Ignition Controller";
    desc = "Register description of the Ignition Controller";

    default regwidth = 8;
    default sw = r;
    default hw = w;

    reg {
        name = "Controller Transceiver State";
        default sw = r;
        default hw = w;

        field {
            desc = "Flag indicating the receiver is aligned to the symbol boundaries";
        } RECEIVER_ALIGNED[1] = 0;
        field {
            desc = "Flag indicating the receiver is receiving valid ordered sets";
        } RECEIVER_LOCKED[1] = 0;
        field {
            desc = "Flag indicating the polarity of the link is inverted";
        } RECEIVER_POLARITY_INVERTED[1] = 0;
    } TRANSCEIVER_STATE;

    reg {
        name = "Controller State";

        field {
            desc = "A Target is present and the TARGET_SYSTEM_TYPE, TARGET_SYSTEM_STATUS and TARGET_SYSTEM_POWER_REQUEST_STATUS registers are valid";
        } TARGET_PRESENT[1] = 0;
    } CONTROLLER_STATE;

    reg {
        name = "Target System Type";
        field {
            desc = "The system type as advertised by the Target";
        } SYSTEM_TYPE[7:0] = 0;
    } TARGET_SYSTEM_TYPE;

    reg {
        name = "Target System Status";

        field {
            desc = "Flag indicating the Target has observed a Controller on link 0";
        } CONTROLLER0_DETECTED[1] = 0;
        field {
            desc = "Flag indicating the Target has observed a Controller on link 1";
        } CONTROLLER1_DETECTED[1] = 0;
        field {
            desc = "Flag indicating system power of the Target system is enabled";
        } SYSTEM_POWER_ENABLED[1] = 0;
        field {
            desc = "Flag indicating system power was turned off due to power fault";
        } SYSTEM_POWER_ABORT[1] = 0;
    } TARGET_SYSTEM_STATUS;

    reg {
        name = "Target System Events";

        field {
            desc = "Flag indicating a power fault in A3";
        } POWER_FAULT_A3[1] = 0;
        field {
            desc = "Flag indicating a power fault in A2";
        } POWER_FAULT_A2[1] = 0;
        field {
            desc = "Reserved fault flag";
        } RESERVED1[1] = 0;
        field {
            desc = "Reserved fault flag";
        } RESERVED2[1] = 0;
        field {
            desc = "";
        } SP[1] = 0;
        field {
            desc = "";
        } ROT[1] = 0;
    } TARGET_SYSTEM_EVENTS;

    reg {
        field {
            desc = "Flag indicating a power off request is in progress";
        } POWER_OFF_IN_PROGRESS[1] = 0;
        field {
            desc = "Flag indicating a power on request is in progress";
        } POWER_ON_IN_PROGRESS[1] = 0;
        field {
            desc = "Flag indicating a system reset request is in progress";
        } POWER_RESET_IN_PROGRESS[1] = 0;
        field {
            desc = "Reserved";
        } RESERVED[1] = 0;
        field {
            hw = r;
            sw = w;
            woclr;
            desc = "Send a system power request; 1 = power off, 2 = power on, 3 = power reset";
        } SYSTEM_POWER_REQUEST[2] = 0;
    } TARGET_SYSTEM_POWER_REQUEST_STATUS;

    link_status TARGET_LINK0_STATUS;
    TARGET_LINK0_STATUS->name = "Target Link 0 Status";

    link_status TARGET_LINK1_STATUS;
    TARGET_LINK1_STATUS->name = "Target Link 1 Status";

    counter TARGET_PRESENT_COUNT @0x80;
    TARGET_PRESENT_COUNT->name = "Target Present Count";
    TARGET_PRESENT_COUNT.COUNT->desc =
        "The number of positive edges on the Target present signal since last reset";

    counter TARGET_TIMEOUT_COUNT;
    TARGET_TIMEOUT_COUNT->name = "Target Timeout Count";
    TARGET_TIMEOUT_COUNT.COUNT->desc =
        "The number of negative edges on the Target present signal since last reset";

    counter TARGET_STATUS_RECEIVED_COUNT;
    TARGET_STATUS_RECEIVED_COUNT->name = "Target Status Received Count";
    TARGET_STATUS_RECEIVED_COUNT.COUNT->desc =
        "The number of Status messages received from the Target since last reset";

    counter TARGET_STATUS_TIMEOUT_COUNT;
    TARGET_STATUS_TIMEOUT_COUNT->name = "Target Status Timeout Count";
    TARGET_STATUS_TIMEOUT_COUNT.COUNT->desc =
        "The number times a Status message failed to be received in the expected time windown since last reset";

    counter CONTROLLER_HELLO_SENT_COUNT;
    CONTROLLER_HELLO_SENT_COUNT->name = "Controller Hello Sent Count";
    CONTROLLER_HELLO_SENT_COUNT.COUNT->desc =
        "The number of Hello messages sent by the Controller since last reset";

    counter CONTROLLER_SYSTEM_POWER_REQUEST_SENT_COUNT;
    CONTROLLER_SYSTEM_POWER_REQUEST_SENT_COUNT->name = "Controller System Power Request Sent Count";
    CONTROLLER_SYSTEM_POWER_REQUEST_SENT_COUNT.COUNT->desc =
        "The number of SystemPowerRequest messages sent by the Controller since last reset";

    counter CONTROLLER_RECEIVER_RESET_COUNT;
    CONTROLLER_RECEIVER_RESET_COUNT->name = "Controller Receiver Reset Count";
    CONTROLLER_RECEIVER_RESET_COUNT.COUNT->desc =
        "The number of times the Controller receiver was reset since last reset";

    counter CONTROLLER_RECEIVER_ALIGNED_COUNT;
    CONTROLLER_RECEIVER_ALIGNED_COUNT->name = "Controller Receiver Aligned Count";
    CONTROLLER_RECEIVER_ALIGNED_COUNT.COUNT->desc =
        "The number of times the Controller receiver transitioned to aligned since last reset";

    counter CONTROLLER_RECEIVER_LOCKED_COUNT;
    CONTROLLER_RECEIVER_LOCKED_COUNT->name = "Controller Receiver Locked Count";
    CONTROLLER_RECEIVER_LOCKED_COUNT.COUNT->desc =
        "The number of times the Controller receiver transitioned to locked since last reset";

    counter CONTROLLER_RECEIVER_POLARITY_INVERTED_COUNT;
    CONTROLLER_RECEIVER_POLARITY_INVERTED_COUNT->name = "Controller Receiver Polarity Inverted Count";
    CONTROLLER_RECEIVER_POLARITY_INVERTED_COUNT.COUNT->desc =
        "The number of times the Controller receiver observed the polarity of the channel to be inverted since last reset";

    counter CONTROLLER_ENCODING_ERROR_COUNT;
    CONTROLLER_ENCODING_ERROR_COUNT->name = "Controller Encoding Error Count";
    CONTROLLER_ENCODING_ERROR_COUNT.COUNT->desc =
        "The number of encoding errors observed by the Controller transmitter since last reset";

    counter CONTROLLER_DECODING_ERROR_COUNT;
    CONTROLLER_DECODING_ERROR_COUNT->name = "Controller Decoding Error Count";
    CONTROLLER_DECODING_ERROR_COUNT.COUNT->desc =
        "The number of decoding errors observed by the Controller receiver since last reset";

    counter CONTROLLER_ORDERED_SET_INVALID_COUNT;
    CONTROLLER_ORDERED_SET_INVALID_COUNT->name = "Controller Ordered Set Invalid Count";
    CONTROLLER_ORDERED_SET_INVALID_COUNT.COUNT->desc =
        "The number of invalid ordered sets observed by the Controller receiver since last reset";

    counter CONTROLLER_MESSAGE_VERSION_INVALID_COUNT;
    CONTROLLER_MESSAGE_VERSION_INVALID_COUNT->name = "Controller Message Version Invalid Count";
    CONTROLLER_MESSAGE_VERSION_INVALID_COUNT.COUNT->desc =
        "The number of messages with invalid version observed by the Controller receiver since last reset";

    counter CONTROLLER_MESSAGE_TYPE_INVALID_COUNT;
    CONTROLLER_MESSAGE_TYPE_INVALID_COUNT->name = "Controller Message Type Invalid Count";
    CONTROLLER_MESSAGE_TYPE_INVALID_COUNT.COUNT->desc =
        "The number of messages with invalid type observed by the Controller receiver since last reset";

    counter CONTROLLER_MESSAGE_CHECKSUM_INVALID_COUNT;
    CONTROLLER_MESSAGE_CHECKSUM_INVALID_COUNT->name = "Controller Message Checksum Invalid Count";
    CONTROLLER_MESSAGE_CHECKSUM_INVALID_COUNT.COUNT->desc =
        "The number of messages with invalid checksum observed by the Controller receiver since last reset";

    counter TARGET_LINK0_RECEIVER_RESET_COUNT;
    TARGET_LINK0_RECEIVER_RESET_COUNT->name = "Target Link 0 Receiver Reset Count";
    TARGET_LINK0_RECEIVER_RESET_COUNT.COUNT->desc =
        "The number of times the Target link 0 receiver was reset since last reset";

    counter TARGET_LINK0_RECEIVER_ALIGNED_COUNT;
    TARGET_LINK0_RECEIVER_ALIGNED_COUNT->name = "Target Link 0 Receiver Aligned Count";
    TARGET_LINK0_RECEIVER_ALIGNED_COUNT.COUNT->desc =
        "The number of times the Target link 0 receiver transitioned to aligned since last reset";

    counter TARGET_LINK0_RECEIVER_LOCKED_COUNT;
    TARGET_LINK0_RECEIVER_LOCKED_COUNT->name = "Target Link 0 Receiver Locked Count";
    TARGET_LINK0_RECEIVER_LOCKED_COUNT.COUNT->desc =
        "The number of times the Target link 0 receiver transitioned to locked since last reset";

    counter TARGET_LINK0_RECEIVER_POLARITY_INVERTED_COUNT;
    TARGET_LINK0_RECEIVER_POLARITY_INVERTED_COUNT->name = "Target Link 0 Receiver Polarity Inverted Count";
    TARGET_LINK0_RECEIVER_POLARITY_INVERTED_COUNT.COUNT->desc =
        "The number of times the Target link 0 receiver observed the polarity of the channel to be inverted since last reset";

    counter TARGET_LINK0_ENCODING_ERROR_COUNT;
    TARGET_LINK0_ENCODING_ERROR_COUNT->name = "Target Link 0 Encoding Error Count";
    TARGET_LINK0_ENCODING_ERROR_COUNT.COUNT->desc =
        "The number of encoding errors observed by the Target link 0 transceiver since last reset";

    counter TARGET_LINK0_DECODING_ERROR_COUNT;
    TARGET_LINK0_DECODING_ERROR_COUNT->name = "Target Link 0 Decoding Error Count";
    TARGET_LINK0_DECODING_ERROR_COUNT.COUNT->desc =
        "The number of decoding errors observed by the Target link 0 transceiver since last reset";

    counter TARGET_LINK0_ORDERED_SET_INVALID_COUNT;
    TARGET_LINK0_ORDERED_SET_INVALID_COUNT->name = "Target Link 0 Ordered Set Invalid Count";
    TARGET_LINK0_ORDERED_SET_INVALID_COUNT.COUNT->desc =
        "The number of invalid ordered sets observed by the Target link 0 transceiver since last reset";

    counter TARGET_LINK0_MESSAGE_VERSION_INVALID_COUNT;
    TARGET_LINK0_MESSAGE_VERSION_INVALID_COUNT->name = "Target Link 0 Message Version Invalid Count";
    TARGET_LINK0_MESSAGE_VERSION_INVALID_COUNT.COUNT->desc =
        "The number of messages with invalid version observed by the Target link 0 transceiver since last reset";

    counter TARGET_LINK0_MESSAGE_TYPE_INVALID_COUNT;
    TARGET_LINK0_MESSAGE_TYPE_INVALID_COUNT->name = "Target Link 0 Message Type Invalid Count";
    TARGET_LINK0_MESSAGE_TYPE_INVALID_COUNT.COUNT->desc =
        "The number of messages with invalid type observed by the Target link 0 transceiver since last reset";

    counter TARGET_LINK0_MESSAGE_CHECKSUM_INVALID_COUNT;
    TARGET_LINK0_MESSAGE_CHECKSUM_INVALID_COUNT->name = "Target Link 0 Message Checksum Invalid Count";
    TARGET_LINK0_MESSAGE_CHECKSUM_INVALID_COUNT.COUNT->desc =
        "The number of messages with invalid checksum observed by the Target link 0 transceiver since last reset";

    counter TARGET_LINK1_RECEIVER_RESET_COUNT;
    TARGET_LINK1_RECEIVER_RESET_COUNT->name = "Target Link 1 Receiver Reset Count";
    TARGET_LINK1_RECEIVER_RESET_COUNT.COUNT->desc =
        "The number of times the Target link 1 receiver was reset since last reset";

    counter TARGET_LINK1_RECEIVER_ALIGNED_COUNT;
    TARGET_LINK1_RECEIVER_ALIGNED_COUNT->name = "Target Link 1 Receiver Aligned Count";
    TARGET_LINK1_RECEIVER_ALIGNED_COUNT.COUNT->desc =
        "The number of times the Target link 1 receiver transitioned to aligned since last reset";

    counter TARGET_LINK1_RECEIVER_LOCKED_COUNT;
    TARGET_LINK1_RECEIVER_LOCKED_COUNT->name = "Target Link 1 Receiver Locked Count";
    TARGET_LINK1_RECEIVER_LOCKED_COUNT.COUNT->desc =
        "The number of times the Target link 1 receiver transitioned to locked since last reset";

    counter TARGET_LINK1_RECEIVER_POLARITY_INVERTED_COUNT;
    TARGET_LINK1_RECEIVER_POLARITY_INVERTED_COUNT->name = "Target Link 1 Receiver Polarity Inverted Count";
    TARGET_LINK1_RECEIVER_POLARITY_INVERTED_COUNT.COUNT->desc =
        "The number of times the Target link 1 receiver observed the polarity of the channel to be inverted since last reset";

    counter TARGET_LINK1_ENCODING_ERROR_COUNT;
    TARGET_LINK1_ENCODING_ERROR_COUNT->name = "Target Link 1 Encoding Error Count";
    TARGET_LINK1_ENCODING_ERROR_COUNT.COUNT->desc =
        "The number of encoding errors observed by the Target link 1 transceiver since last reset";

    counter TARGET_LINK1_DECODING_ERROR_COUNT;
    TARGET_LINK1_DECODING_ERROR_COUNT->name = "Target Link 1 Decoding Error Count";
    TARGET_LINK1_DECODING_ERROR_COUNT.COUNT->desc =
        "The number of decoding errors observed by the Target link 1 transceiver since last reset";

    counter TARGET_LINK1_ORDERED_SET_INVALID_COUNT;
    TARGET_LINK1_ORDERED_SET_INVALID_COUNT->name = "Target Link 1 Ordered Set Invalid Count";
    TARGET_LINK1_ORDERED_SET_INVALID_COUNT.COUNT->desc =
        "The number of invalid ordered sets observed by the Target link 1 transceiver since last reset";

    counter TARGET_LINK1_MESSAGE_VERSION_INVALID_COUNT;
    TARGET_LINK1_MESSAGE_VERSION_INVALID_COUNT->name = "Target Link 1 Message Version Invalid Count";
    TARGET_LINK1_MESSAGE_VERSION_INVALID_COUNT.COUNT->desc =
        "The number of messages with invalid version observed by the Target link 1 transceiver since last reset";

    counter TARGET_LINK1_MESSAGE_TYPE_INVALID_COUNT;
    TARGET_LINK1_MESSAGE_TYPE_INVALID_COUNT->name = "Target Link 1 Message Type Invalid Count";
    TARGET_LINK1_MESSAGE_TYPE_INVALID_COUNT.COUNT->desc =
        "The number of messages with invalid type observed by the Target link 1 transceiver since last reset";

    counter TARGET_LINK1_MESSAGE_CHECKSUM_INVALID_COUNT;
    TARGET_LINK1_MESSAGE_CHECKSUM_INVALID_COUNT->name = "Target Link 1 Message Checksum Invalid Count";
    TARGET_LINK1_MESSAGE_CHECKSUM_INVALID_COUNT.COUNT->desc =
        "The number of messages with invalid checksum observed by the Target link 1 transceiver since last reset";
};
