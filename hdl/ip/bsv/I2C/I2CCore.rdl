// Copyright 2022 Oxide Computer Company
//
// This Source Code Form is subject to the terms of the Mozilla Public
// License, v. 2.0. If a copy of the MPL was not distributed with this
// file, You can obtain one at https://mozilla.org/MPL/2.0/.

addrmap I2C_core {
    name = "I2C Core Registers";
    desc = "Register description for the I2C Core's control registers";

    default regwidth = 8;
    default sw = rw;
    default hw = r;

    reg {
        name = "Address Byte";

        field {
            desc = "Address to transmit";
        } ADDR[7:1] = 0;

        field {
            desc = "Read/write bit. '1' if reading from peripheral, '0' if writing to it.";
        } RW[0:0] = 0;
    } ADDRESS;

    reg {
        name = "Receive data";
        default sw = r;
        default hw = rw;

        field {
            desc = "Last byte recieved";
        } DATA[7:0] = 0;
    } RECEIVE;

    reg {
        name = "Transmit data";
        default sw = r;
        default hw = rw;

        field {
            desc = "Next byte to send";
        } DATA[7:0] = 0;
    } TRANSMIT;

    reg {
        name = "Control bits for I2C Core";

        field {
            desc = "Begin a transaction";
        } START[0:0] = 0;
    } CONTROL;

    reg {
        name = "Status";
        default sw = r;
        default hw = rw;

        field {
            desc = "I2C bus is busy. '1' after a START, '0' after a STOP.";
        } ERR[0:0] = 0;

        field {
            desc = "'1' while core is idling, '0' otherwise.";
        } DONE[1:1] = 0;

        field {
            desc = "'1' while core is in a transaction, '0' otherwise";
        } BUSY[0:0] = 0;
    } STATUS;
};