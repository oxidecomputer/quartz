// Platform-specific registers in the eSPI configuration space. The eSPI
// specification sets 0x800 and up aside for these, so they are read with
// GET_CONFIGURATION like the specification's own registers but are kept in
// their own map: the specification registers are mirrored into the SP's
// register space, where there is no room this far up.

addrmap eSPI_Platform {
    name = "espi platform registers";
    desc = "Oxide registers in the platform-specific part of the eSPI configuration space";

    default regwidth = 32;
    default sw = r;
    default hw = r;

    reg {
        name = "Board Identification";
        desc = "Which Oxide board this eSPI target is on, so the host can tell them apart";

        enum board_kind {
            COSMO = 8'h00 {desc = "";};
            METRO = 8'h01 {desc = "";};
        };

        field {
            desc = "Board";
            encode = board_kind;
        } board[7:0] = 0x00;

    } board_id @0x800;

    reg {
        name = "NIC image hash control";
        desc = "Metro only; reads as zero elsewhere. The FPGA measures the NIC's boot image
        (sha3-256 over the range the SP has set in the hash engine) at every NIC power-up and
        holds the NIC in reset until the host enables slot power. This register is the host's
        handle on that measurement. Both bits are written with a 1 to act, 0 does nothing.";

        field {
            desc = "Set by hardware when a measurement has finished and nic_hash0..7 hold its
            digest. Write 1 to clear it; nic_hash0..7 then read as zero until the next
            measurement finishes. Also cleared by hardware when a write or erase goes to the
            flash over this eSPI link, since the digest no longer describes the image; a
            measurement running while that happens finishes without setting it.";
            sw = rw;
        } done[0:0] = 0;
        field {
            desc = "Write 1 to have the image measured again. Reads 1 while the request is
            waiting (the NIC is being configured and has the flash) or the measurement is
            running; hardware clears it when the measurement finishes, at which point done is
            set. Writing while a measurement runs queues one more.";
            sw = rw;
        } rehash[1:1] = 0;
    } nic_hash_ctrl @0x804;

    reg {
        name = "NIC configuration control";
        desc = "Metro only; reads as zero elsewhere. The host's say-so for configuring the
        NIC from the image it has measured.";

        field {
            desc = "Set once the digest in nic_hash0..7 is acceptable: the FPGA then straps
            the boot mode, releases POR_B and waits for the NIC's DONE, see
            nic_config_status. Clear to put the NIC back in reset at the interlock: PERST
            asserted, presence withdrawn, nic_config_status back to IDLE; the digest is
            kept, so setting it again configures without measuring again. Kept across an
            eSPI reset, so a host reboot leaves the NIC running; cleared when the host
            leaves A0, so each A0 entry starts with the NIC held at the interlock.";
            sw = rw;
        } mission_mode_en[0:0] = 0;
    } nic_config_ctrl @0x808;

    reg {
        name = "NIC configuration status";
        desc = "Metro only; reads as zero elsewhere. Where the NIC's configuration stands.";
        default sw = r;

        enum config_state {
            IDLE = 2'h0 {desc = "Not configuring: the NIC is off, or held in reset waiting for mission_mode_en";};
            IN_PROGRESS = 2'h1 {desc = "POR_B released, waiting for DONE";};
            DONE = 2'h2 {desc = "Configured; presence is shown and PERST follows the slot";};
            FAILED = 2'h3 {desc = "ERROR_OUT, or no DONE within nic_config_timeout. Back in reset with the flash on eSPI1; clear and set mission_mode_en to try again";};
        };
        field {
            desc = "Configuration state";
            encode = config_state;
        } state[1:0] = 0;
        field {
            desc = "The failure was the timeout rather than ERROR_OUT";
        } timed_out[2:2] = 0;
        field {
            desc = "ERROR_OUT as the NIC drives it now";
        } error_out[3:3] = 0;
    } nic_config_status @0x80c;

    reg {
        name = "NIC configuration timeout";
        desc = "Metro only. How long after POR_B is released the NIC has to assert DONE
        before its configuration is failed, in milliseconds. Kept across eSPI resets and
        the host leaving A0.";

        field {
            desc = "Milliseconds";
            sw = rw;
        } ms[31:0] = 10000;
    } nic_config_timeout @0x810;

    reg {
        name = "NIC image hash range start";
        desc = "Metro only; reads as zero elsewhere. The flash byte address the measurement
        in nic_hash0..7 starts at, as the SP has set it in the hash engine (metro: 0).";
        default sw = r;
        field {
            desc = "Flash byte address";
        } addr[31:0] = 0;
    } nic_hash_addr @0x814;

    reg {
        name = "NIC image hash range length";
        desc = "Metro only; reads as zero elsewhere. How many bytes the measurement in
        nic_hash0..7 covers, as the SP has set it in the hash engine (metro: 32MiB).";
        default sw = r;
        field {
            desc = "Bytes";
        } count[31:0] = 0;
    } nic_hash_len @0x818;

    // The digest is presented least significant word first, as the hash
    // engine's own DIGEST registers are: nic_hash0 bits 7:0 are hash byte 0,
    // the leftmost byte of the conventional hex string. All eight words read
    // as zero unless nic_hash_ctrl.done is set.
    reg nic_hash_word {
        default sw = r;
        default hw = w;

        field {
            desc = "32 bits of the digest";
        } data[31:0] = 0;
    };

    nic_hash_word nic_hash0 @0x820;
    nic_hash0->desc = "Digest bytes 0 to 3";
    nic_hash_word nic_hash1 @0x824;
    nic_hash1->desc = "Digest bytes 4 to 7";
    nic_hash_word nic_hash2 @0x828;
    nic_hash2->desc = "Digest bytes 8 to 11";
    nic_hash_word nic_hash3 @0x82c;
    nic_hash3->desc = "Digest bytes 12 to 15";
    nic_hash_word nic_hash4 @0x830;
    nic_hash4->desc = "Digest bytes 16 to 19";
    nic_hash_word nic_hash5 @0x834;
    nic_hash5->desc = "Digest bytes 20 to 23";
    nic_hash_word nic_hash6 @0x838;
    nic_hash6->desc = "Digest bytes 24 to 27";
    nic_hash_word nic_hash7 @0x83c;
    nic_hash7->desc = "Digest bytes 28 to 31";
};
