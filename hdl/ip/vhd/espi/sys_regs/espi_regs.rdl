// Copyright 2024 Oxide Computer Company
// This is SystemRDL description of the sw-accessible registers in the Gimlet
// Sequencer FPGA.

property addr_span_bytes {
    type=number;
    component=addrmap;
    default=0x100;
    };

addrmap espi_regs {
    
    name = "espi system registers";
    desc = "Registers accessible on the Axi bus for debug and testing of the espi target";

    default regwidth = 32;
    default sw = rw;
    default hw = r;

    reg {
        name = "Flags Register";
        desc = "";

        field {
            default sw = woclr;
            desc = "Sticky bit for alert, set to 1 when alert is needed, cleared by writing 1";
        } alert[0:0] =  0;
    } flags;

    reg {
        name = "Control Register";
        desc = "";
        field {
            desc = "Issue an espi reset via the debug logic. Cleared by hardware after reset.";
        } espi_reset[5:5] =  0;
        field {
            desc = "Set to one to reset the command FIFO. Cleared by hardware after reset.";
        } cmd_fifo_reset[3:3] =  0;
         field {
            desc = "Set to one to reset the command size FIFO. Cleared by hardware after reset.";
        } cmd_size_fifo_reset[2:2] =  0;
        field {
            desc = "Set to one to reset response FIFO. Cleared by hardware after reset.";
        } resp_fifo_reset[1:1] =  0;
        field {
            desc = "Set to one mux in the debug FIFOs and ignore the real eSPI interface";
        } dbg_mode_en[0:0] =  0;   
    } control;

    reg {
        name = "Status Register";
        desc = "";

        field {
            default sw = r;
            desc = "Set to one to 1 when hw is running the spi transaction, no new transactions
            may be issued until it is finished. Technically represents cs_n being low.";
        } busy[0:0] =  0;

    } status;

    reg {
        name = "Fifo Status Register";
        desc = "";
        field {
            default sw = r;
            desc = "Show used words in command FIFO (word = 32bits/4 bytes),
            1024 words so 4kB";
        } cmd_used_wds[31:16] =  0;

        field {
            default sw = r;
            desc = "Show used FIFO words in response FIFO (word = 32bits/4 bytes),
            1024 words so 4kB";
        } resp_used_wds[15:0] =  0;
    } fifo_status;

    reg {
        name = "Command FIFO Write Data Register";
        desc = "";
        field {
            desc = "Writing stores data in fifo";
        } fifo_data[31:0] =  0;
     } cmd_fifo_wdata;

    reg {
        name = "Response FIFO Read Data Register";
        desc = "";
        field {
            desc = "Note: Reading side-effects the data by popping the fifo";
        } fifo_data[31:0] =  0;
    } resp_fifo_rdata;

    reg {
        name = "Command FIFO Byte Count FIFO";
        desc = "";
        field {
            desc = "store command byte size in fifo. Because we are sending 4bytes at a time into the fifo, but only reading
            1 byte at a time, we need to store the number of cmd bytes in the fifo. This allows queueing up multiple commands
            if desired. left over data bytes are discarded if this fifo is empty and there are <4 bytes left in cmd_fifo";
        } fifo_data[7:0] =  0;
     } cmd_size_fifo_wdata;

    reg {
        name = "UART Avail Threshold Bytes";
        desc = "";
        field {
            desc = "";
        } bytes[7:0] =  32;
     } uart_thresh;

    reg {
        name = "Last Post Code (0x47 PUT_IOWR_SHORT) Payload";
        desc = "";
        field {
            desc = "MSB is bit 31";
        } payload[31:0] =  0;
    } last_post_code;

    reg {
        name = "Post Code Counter";
        desc = "Count of valid post codes seen since reset. Can also be reset by espi_reset.";
        field {
            desc = "";
        } count[31:0] = 0;
    } post_code_count;

    reg {
        name = "IPCC_TO_HOST_USEDWDS";
        desc = "Count of usedwds in the IPCC to host TX FIFO";
        field {
            desc = "";
        } count[31:0] = 0;
    } ipcc_to_host_usedwds;

    reg {
        name = "IPCC_TO_HOST_BYTE_CNTR";
        desc = "Count of total bytes sent to host via IPCC UART channel since reset";
        field {
            desc = "";
        } count[31:0] = 0;
    } ipcc_to_host_byte_cntr;

    reg {
        name = "IPCC DUMMY FILL EN";
        desc = "Enable this to do a 1 time FIFO fill with dummy count (next register) bytes into the ipcc FIFO when oob channel is enabled";
        field {
            desc = "";
        } en[0:0] = 0;
    } ipcc_dummy_fill_en;

    reg {
        name = "IPCC DUMMY FILL COUNT";
        desc = "Count of dummy bytes to be filled into IPCC FIFO when dummy fill is enabled. 1 time fill on enable after espi reset.";
        field {
            desc = "";
        } count[31:0] = 0;
    } ipcc_dummy_fill_count;

     mem post_code_buffer_mem {
        mementries = 4096;
        memwidth = 32;
    };

    external post_code_buffer_mem post_code_buffer @0x0100;
};