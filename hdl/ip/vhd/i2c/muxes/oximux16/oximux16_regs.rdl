// Copyright 2025 Oxide Computer Company
// This is SystemRDL description of emulated i2c mux registers

addrmap oximux16_regs {
    name = "oximux16 registers";
    desc = "Registers accessible on the i2c bus for controlling the oximux16 i2c mux";

    default regwidth = 8;
    default sw = rw;
    default hw = r;

    reg {
        name = "Control Register 0";
        desc = "";
        field {
            desc = "Channel 7: 0 = disable, 1 = enable";
        } B7[7:7] =  0;
        field {
            desc = "Channel 6: 0 = disable, 1 = enable";
        } B6[6:6] =  0;
        field {
            desc = "Channel 5: 0 = disable, 1 = enable";
        } B5[5:5] =  0;
        field {
            desc = "Channel 4: 0 = disable, 1 = enable";
        } B4[4:4] =  0;
        field {
            desc = "Channel 3: 0 = disable, 1 = enable";
        } B3[3:3] =  0;
        field {
            desc = "Channel 2: 0 = disable, 1 = enable";
        } B2[2:2] =  0;
        field {
            desc = "Channel 1: 0 = disable, 1 = enable";
        } B1[1:1] =  0;
        field {
            desc = "Channel 0: 0 = disable, 1 = enable";
        } B0[0:0] =  0;
    } control0;

     reg {
        name = "Control Register 1";
        desc = "";
        field {
            desc = "Channel 15: 0 = disable, 1 = enable";
        } B15[7:7] =  0;
        field {
            desc = "Channel 14: 0 = disable, 1 = enable";
        } B14[6:6] =  0;
        field {
            desc = "Channel 13: 0 = disable, 1 = enable";
        } B13[5:5] =  0;
        field {
            desc = "Channel 12: 0 = disable, 1 = enable";
        } B12[4:4] =  0;
        field {
            desc = "Channel 11: 0 = disable, 1 = enable";
        } B11[3:3] =  0;
        field {
            desc = "Channel 10: 0 = disable, 1 = enable";
        } B10[2:2] =  0;
        field {
            desc = "Channel 9: 0 = disable, 1 = enable";
        } B9[1:1] =  0;
        field {
            desc = "Channel 8: 0 = disable, 1 = enable";
        } B8[0:0] =  0;
    } control1;

};