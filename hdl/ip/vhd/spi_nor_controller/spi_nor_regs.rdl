// This Source Code Form is subject to the terms of the Mozilla Public
// License, v. 2.0. If a copy of the MPL was not distributed with this
// file, You can obtain one at https://mozilla.org/MPL/2.0/.
//
// Copyright 2024 Oxide Computer Company
//
// This is SystemRDL description of the sw-accesible registers in the
// grapefruit dev board FPGA.

addrmap spi_nor_regs {
    name = "SPI/QSPI NOR flash controller";
    desc = "";

    default regwidth = 32;
    default sw = rw;
    default hw = r;

    reg {
        name = "SPI Control Register";
        desc = "";
        field {
            desc = "Set to one to allow eSPI <-> SP5 interface read from flash. Hubris should
            not attempt any flash accesses with this bit set. This bit also enforces the
            flash offset in ";
        } sp5_owns_flash[31:31] =  0;
        
        field {
            desc = "Set to one to reset RX FIFO. Cleared by hardware after reset.";
        } rx_fifo_reset[15:15] =  0;
        field {
            desc = "Set to one to reset TX FIFO. Cleared by hardware after reset.";
        } tx_fifo_reset[7:7] =  0;

    } SPICR;
    reg {
        name = "SPI Status Register";
        desc = "";
        field {
            default sw = r;
            desc = "Show used FIFO words in TX_FIFO (word = 32bits/4 bytes),
            max of 256 bytes, so 64 words";
        } tx_used_wds[30:24] =  0;
        field {
            default sw = r;
            desc = "Set to one to 1 when TX FIFO is full";
        } tx_full[23:23] =  0;
         field {
            default sw = r;
            desc = "Set to one to 1 when TX FIFO is empty";
        } tx_empty[22:22] =  0;
        field {
            default sw = r;
            desc = "Show used FIFO words in RX_FIFO (word = 32bits/4 bytes),
            max of 256 bytes, so 64 words";
        } rx_used_wds[14:8] =  0;
        field {
            default sw = r;
            desc = "Set to one to 1 when RX FIFO is full";
        } rx_full[7:7] =  0;
         field {
            default sw = r;
            desc = "Set to one to 1 when RX FIFO is empty";
        } rx_empty[6:6] =  0;

        field {
            default sw = r;
            desc = "Set to one to 1 when hw is running the spi transaction, no new transactions
            may be issued until it is finished. Technically represents cs_n being low.";
        } busy[0:0] =  0;

    } SPISR;
    // address reg
    reg {
        name = "Target Address Register";
        desc = "";
        field {
            desc = "Address to be used for 24 or 32bit accesses";
        } addr[31:0] =  0;
     } Addr;
    // dummy cycles reg
    reg {
        name = "Dummy Cycles Register";
        desc = "";
        field {
            desc = "Specify # of dummy cycles required for this instruction";
        } count[7:0] =  0;
     } DummyCycles;

    reg {
        name = "Data Byte Count Register";
        desc = "";
        field {
            desc = "Specify # data bytes -1 (not counting instruction, addr or dummy cycles to be transferred),
            max of 255 here representing 255 + 1 as that's the largest transaction the flash can support";
        } count[8:0] =  0;
     } DataBytes;
    
    reg {
        name = "SPI Instruction Register";
        desc = "";
        field {
            desc = "SPI Opcode used in the instruction phase. Write side-effect: starts a new transaction.
            This should be the last register written to during setup";
        } opcode[7:0] =  0;
    } Instr;

    reg {
        name = "TX FIFO Write Data Register";
        desc = "";
        field {
            desc = "Writing stores data in fifo";
        } fifo_data[31:0] =  0;
     } tx_fifo_wdata;

    reg {
        name = "RX FIFO Read Data Register";
        desc = "";
        field {
            desc = "Note: Reading side-effects the data by popping the fifo";
        } fifo_data[31:0] =  0;
     } rx_fifo_rdata;

    reg {
        name = "SP5 Flash offset address";
        desc = "Allows the SP to control which flash page is accessed by the eSPI block";
        field {
            desc = "*Signed* Address added (ie subtracted for negative) to raw eSPI transactions to generate physical flash address";
        } offset[31:0] =  0;
    } SP5FlashOffset;

    reg {
        name = "APOB Flash location address";
        desc = "Allows the SP to configure the start of the flash range which is remapped to APOB flash region";
        field {
            desc = "Start address of the APOB flash region";
        } offset[31:0] = 0;
    } ApobFlashAddr;

    reg {
        name = "APOB Flash length";
        desc = "Allows the SP to configure the length of the flash range which is remapped to APOB flash region";
        field {
            desc = "Length of the APOB flash region";
        } offset[31:0] = 0;
    } ApobFlashLen;

    reg {
        name = "APOB Flash offset address";
        desc = "Allows the SP to configure the selected APOB region via its absolute address in flash";
        field {
            desc = "Offset of the APOB flash slot";
        } offset[31:0] = 0;
    } ApobFlashOffset;
};
