// Copyright 2025 Oxide Computer Company
// This is SystemRDL description of the sw-accessible registers in the Cosmo
// Debug Control FPGA block.

addrmap debug_regs {
    name = "Cosmo Debug Control/Status block";
    desc = "";

    default regwidth = 32;
    default sw = rw;
    default hw = r;
 
    reg {
           name = "UART Debug Control";
           field {
               desc = "Set to 1 to send the SP5's console UART out the UART debug header. By default
               this is muxed to the SP's console UART, setting this takes the data away from the SP and 
               sends it out the debug header with flow control.";
           } sp5_to_header[0:0] = 0;
    } uart_control;

    reg {
           name = "SP Console UART (AXI->UART) FIFO USEDWDS Status";
           field {
               desc = "Number of FIFO bytes pending transmit *to* the SP, should stay near 0 when the SP is
               receiving bytes at a reasonable rate. This is effectively 1/2 the buffer in this flow as the
               UART to the SP5 also has a FIFO.";
           } usedwds[7:0] = 0;
       } sp_axi_to_console_uart_usedwds;
    
    reg {
          name = "SP Console UART (UART->AXI) FIFO USEDWDS Status";
          field {
              desc = "Number of FIFO bytes pending transmit *to* the SP5, should stay near 0 when the SP5 is
              receiving bytes at a reasonable rate. This is effectively 1/2 the buffer in this flow as the
              UART to the SP5 also has a FIFO.";
          } usedwds[7:0] = 0;
      } sp_console_uart_to_axi_usedwds;

    reg {
           name = "SP5 Console UART (AXI->UART) FIFO USEDWDS Status";
           field {
               desc = "Number of FIFO bytes pending transmit *to* the SP5, should stay near 0 when the SP5 is
               receiving bytes at a reasonable rate. This is effectively 1/2 the buffer in this flow as the
               UART to the SP also has a FIFO.";
           } usedwds[7:0] = 0;
       } sp5_axi_to_console_uart_usedwds;
    
    reg {
          name = "SP5 Console UART (UART->AXI) FIFO USEDWDS Status";
          field {
              desc = "Number of FIFO bytes pending transmit *to* the SP, should stay near 0 when the SP is
              receiving bytes at a reasonable rate. This is effectively 1/2 the buffer in this flow as the
              UART to the SP also has a FIFO.";
          } usedwds[7:0] = 0;
      } sp5_console_uart_to_axi_usedwds;
    
    reg {
        name = "Live status of the various hw handshake signals for the respective UART:";

        field {
            desc = "SP ipcc UART RTS_L (from SP pins, input to FPGA)";
        } ipcc_sp_rts_l[9:9] = 0;
        field {
            desc = "SP ipcc UART CTS_L (from SP pins, input to FPGA)";
        } ipcc_sp_cts_l[8:8] = 0;
        field {
            desc = "SP console UART RTS_L (from SP pins, input to FPGA)";
        } console_sp_rts_l[5:5] = 0;
        field {
            desc = "SP console UART CTS_L (to SP5 pins, output from FPGA)";
        } console_sp_cts_l[4:4] = 0;
        field {
            desc = "SP5 console UART RTS_L (from SP5 pins, input to FPGA)";
        } console_sp5_rts_l[1:1] = 0;
        field {
            desc = "SP5 console UART CTS_L (to SP5 pins, output from FPGA)";
        } console_sp5_cts_l[0:0] = 0;

    } uart_pin_status;

    reg {
           name = "SP IPCC UART (AXI->UART) FIFO USEDWDS Status";
           field {
               desc = "Number of FIFO bytes pending transmit *to* the SP, should stay near 0 when the SP is
               receiving bytes at a reasonable rate (from SP5 over eSPI).";
           } usedwds[7:0] = 0;
       } sp5_axi_to_ipcc_uart_usedwds;
    
    reg {
          name = "SP IPCC UART (UART->AXI) FIFO USEDWDS Status";
          field {
              desc = "Number of FIFO bytes pending transmit *to* the SP5, should average near 0 when the SP5 is
              receiving bytes at a reasonable rate, but is bursty over eSPI.";
          } usedwds[7:0] = 0;
      } sp5_ipcc_uart_to_axi_usedwds;

    reg {
        name = "SP5 DBG2 toggle counter";
        field {
            desc = "Saturating u32 counter that counts the number of times the SP5 DBG2 pin has toggled in this a0 power cycle. ";
        } cnts[31:0] = 0;
    } sp5_dbg2_toggle_counter;
    reg {
        name = "SP5 DBG2 toggle timer";
        field {
            desc = "Saturating u32 counter that counts the number 8ns clock cycles since last SP5 DBG2 pin toggle in this a0 power cycle.";
        } cnts[31:0] = 0;
    } sp5_dbg2_toggle_timer;

    reg {
        name = "1V8 Header Debug Control";
         
         enum debug_mux_sel {
            NONE = 8'h00 {desc = "No Outputs assigned here";};
            i2c_dimm0_bus = 8'h01 {desc = "FPGA -> DIMM0 i2c bus to pins";};
            i2c_dimm1_bus = 8'h02 {desc = "FPGA -> DIMM1 i2c bus to pins";};
            i2c_sp5_dimm0_bus = 8'h03 {desc = "SP5 -> FPGA DIMM0 i2c bus to pins";};
            i2c_sp5_dimm1_bus = 8'h04 {desc = "SP5 -> FPGA DIMM1 i2c bus to pins";};
            i2c_sp5_hp_bus = 8'h05 {desc = "SP5 -> FPGA Hotplug i2c bus to pins";};
            i2c_sp_mux_bus = 8'h06 {desc = "SP -> FPGA MUX i2c bus to pins";};
            espi_bus = 8'h07 {desc = "SP5 -> eSPI bus to pins";};
            sp_console_bus = 8'h08 {desc = "SP <-> FPGA console UART to pins";};
            sp5_console_bus = 8'h09 {desc = "SP5 <-> FPGA console UART to pins";};
            sp_ipcc_bus = 8'h0a {desc = "SP <-> FPGA IPCC UART to pins";};
            t6_sequencer = 8'h0b {desc = "T6 sequencer debug output to pins";};
        };
        field {
            desc = "Selects which debug output is sent to the 1v8 debug header in sets of two pins.
            For i2c buses the highest bit is the clock, the next bit is the data.
            For UARTs the highest bit is the 'from FPGA' side the next bit is the 'to FPGA' side.
            Espi buses have defined pins (TBD) to match standard debug setup.";
            encode = debug_mux_sel;
        } pins7_6[31:24] = 0;
        field {
            desc = "Selects which debug output is sent to the 1v8 debug header in sets of two pins.
            For i2c buses the highest bit is the clock, the next bit is the data.
            For UARTs the highest bit is the 'from FPGA' side the next bit is the 'to FPGA' side.
            Espi buses have defined pins (TBD) to match standard debug setup.";
            encode = debug_mux_sel;
        } pins5_4[23:16] = 0;
        field {
            desc = "Selects which debug output is sent to the 1v8 debug header in sets of two pins.
            For i2c buses the highest bit is the clock, the next bit is the data.
            For UARTs the highest bit is the 'from FPGA' side the next bit is the 'to FPGA' side.
            Espi buses have defined pins (TBD) to match standard debug setup.";
            encode = debug_mux_sel;
        } pins3_2[15:8] = 0;
        field {
            desc = "Selects which debug output is sent to the 1v8 debug header in sets of two pins.
            For i2c buses the highest bit is the clock, the next bit is the data.
            For UARTs the highest bit is the 'from FPGA' side the next bit is the 'to FPGA' side.
            Espi buses have defined pins (TBD) to match standard debug setup.";
            encode = debug_mux_sel;
        } pins1_0[7:0] = 0;
    } dbg_1v8_ctrl;

    reg {
        name = "Debug Convenience";
         field {
            desc = "convenience bit for setting up T6 sequencing debug out. This uses 1v8 debug header pins 7..0. Hw clears";
        } t6_seq_en[2:2] = 0;
        field {
            desc = "convenience bit for setting up x4 espi debug out. This uses 1v8 debug header pins 7..0. Hw clears";
        } espi_dbg_x4_en[1:1] = 0;
        field {
            desc = "convenience bit for setting up x1 espi debug out.. This uses 1v8 debug header pins 7..2. Hw clears";
        } espi_dbg_x1_en[0:0] = 0;
    } dbg_convenience;
};