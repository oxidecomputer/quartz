// Copyright 2025 Oxide Computer Company
// This is SystemRDL description of the sw-accessible registers for the DDR SPD Proxy block and
// related DIMM registers.

addrmap dimm_regs {
    name = "dimms";
    desc = "SPD proxy and general DIMM registers.";

    default regwidth = 32;
    default sw = rw;
    default hw = r;

    //
    // General DIMM registers
    //

    reg {
        name = "DIMM PCAMP Readbacks";
        desc = "Live status from the sampled pins";
        default sw = r;
        field {
            desc = "DIMM L pcamp pin readback";
        } pcamp_l[13:13];
        field {
            desc = "DIMM K pcamp pin readback";
        } pcamp_k[12:12];
        field {
            desc = "DIMM J pcamp pin readback";
        } pcamp_j[11:11];
        field {
            desc = "DIMM I pcamp pin readback";
        } pcamp_i[10:10];
        field {
            desc = "DIMM H pcamp pin readback";
        } pcamp_h[9:9];
        field {
            desc = "DIMM G pcamp pin readback";
        } pcamp_g[8:8];

        field {
            desc = "DIMM F pcamp pin readback";
        } pcamp_f[5:5];
        field {
            desc = "DIMM E pcamp pin readback";
        } pcamp_e[4:4];
        field {
            desc = "DIMM D pcamp pin readback";
        } pcamp_d[3:3];
        field {
            desc = "DIMM C pcamp pin readback";
        } pcamp_c[2:2];
        field {
            desc = "DIMM B pcamp pin readback";
        } pcamp_b[1:1];
        field {
            desc = "DIMM A pcamp pin readback";
        } pcamp_a[0:0];
    } dimm_pcamp;

    reg {
        name = "SPD Present";
        desc = "Indicates if the DIMM is present (via SPD ack)";
        default sw = r;
        field {
            desc = "DIMM L present (spd ack'd)";
        } bus1_l[13:13];
        field {
            desc = "DIMM K present (spd ack'd)";
        } bus1_k[12:12];
        field {
            desc = "DIMM J present (spd ack'd)";
        } bus1_j[11:11];
        field {
            desc = "DIMM I present (spd ack'd)";
        } bus1_i[10:10];
        field {
            desc = "DIMM H present (spd ack'd)";
        } bus1_h[9:9];
        field {
            desc = "DIMM G present (spd ack'd)";
        } bus1_g[8:8];

        field {
            desc = "DIMM F present (spd ack'd)";
        } bus0_f[5:5];
        field {
            desc = "DIMM E present (spd ack'd)";
        } bus0_e[4:4];
        field {
            desc = "DIMM D present (spd ack'd)";
        } bus0_d[3:3];
        field {
            desc = "DIMM C present (spd ack'd)";
        } bus0_c[2:2];
        field {
            desc = "DIMM B present (spd ack'd)";
        } bus0_b[1:1];
        field {
            desc = "DIMM A present (spd ack'd)";
        } bus0_a[0:0];
    } spd_present;

    //
    // SPD Cache Registers
    //

    reg {
        name = "spd_cache_select";
        desc = "Choose which DIMM SPD cache to read from. Addresses match present bit index in the spd_present register ";

        field {
            desc = "DIMM L selected";
        } bus1_l[13:13];
        field {
            desc = "DIMM K selected";
        } bus1_k[12:12];
        field {
            desc = "DIMM J selected";
        } bus1_j[11:11];
        field {
            desc = "DIMM I selected";
        } bus1_i[10:10];
        field {
            desc = "DIMM H selected";
        } bus1_h[9:9];
        field {
            desc = "DIMM G selected";
        } bus1_g[8:8];

        field {
            desc = "DIMM F selected";
        } bus0_f[5:5];
        field {
            desc = "DIMM E selected";
        } bus0_e[4:4];
        field {
            desc = "DIMM D selected";
        } bus0_d[3:3];
        field {
            desc = "DIMM C selected";
        } bus0_c[2:2];
        field {
            desc = "DIMM B selected";
        } bus0_b[1:1];
        field {
            desc = "DIMM A selected";
        } bus0_a[0:0];
    } spd_select;

    reg {
        name = "spd_ctrl";
        desc = "Pre-fetch the SPD data from the DIMMs";

         field {
            desc = "Set to initiate a SPD cache read. Cleared by hardware after the read is complete.";
        } start[0:0] =  0;
    } spd_ctrl;

    reg {
        desc = "Current read_ptr in SPD Cache for selected DIMM";
        field {
            desc = "in 32bit words, can write to move around 0-255 for 1024 bytes in 32bit words";
        } addr[7:0] =  0;
    } spd_rd_ptr;

    reg {
        desc = "Current read-data for selected DIMM, reading auto-increments the read pointer";
        default sw = r;
        field {
            desc = "in 32bit words";
        } data[31:0] =  0;
    } spd_rdata;

    //
    // DIMM Transaction Buffers
    //

    reg {
        name = "fifo_ctrl";
        desc = "Control of the fifos, shared settings for both DIMM busses";

        field {
            desc = "Set to one to reset RX FIFO. Cleared by hardware after FIFO reset.";
        } rx_fifo_reset[15:15] =  0;
        field {
            desc = "Set to one put RX FIFO in auto increment mode.";
        } rx_fifo_auto_inc[14:14] =  1;
        field {
            desc = "Set to one to reset TX FIFO. Cleared by hardware after FIFO reset.";
        } tx_fifo_reset[7:7] =  0;
         field {
            desc = "Set to one put TX FIFO in auto increment mode.";
        } tx_fifo_auto_inc[6:6] =  1;
    } fifo_ctrl;

    reg tx_fifo_wdata{
        name = "TX FIFO Write Data Register";
        desc = "";
        default sw = w;
        field {
            desc = "Writing stores data in fifo";
        } data[31:0] =  0;
    };

    reg tx_fifo_waddr {
        name = "TX FIFO WDATA Data Pointer";
        default sw = r;
        desc = "";
        field {
            desc = "Live pointer in 32bit words to DPR";
        } addr[31:0] =  0;
    };

    reg rx_fifo_raddr {
        name = "RX FIFO Read Data Pointer";
        default sw = r;
        desc = "";
        field {
            desc = "Live pointer in 32bit words to DPR";
        } addr[31:0] =  0;
    };

    reg rx_byte_count{
        name = "RX FIFO Available Data";
        desc = "";
        default sw = r;
        field {
            desc = "Byte count of data in RX FIFO";
        } data[31:0] =  0;
    };

    reg rx_fifo_rdata{
        name = "RX FIFO Read Data Register";
        desc = "";
        default sw = r;
        field {
            desc = "Note: in auto-inc mode. reading side-effects the data by moving the raddr pointer";
        } data[31:0] =  0;
    };

    reg cmd {
        name = "command";
        desc = "Allow manual control over some I/O for debugging purposes, a write here initiates the command";

        field {
            desc = "READ=0b00, WRITE= 0b01, RANDOM=0b10";
        } op[25:24] = 0;

        field {
            desc = "i2c/i3c bus address";
        } bus_addr[22:16] = 0;

        field {
            desc = "Register address";
        } reg_addr[15:8] = 0;

        field {
            desc = "length of the payload in bytes";
        } len[7:0] = 0;
    };

    cmd bus0_cmd;
    bus0_cmd->name = "command for the abcdef DIMM bus";
    tx_fifo_wdata bus0_tx_wdata;
    bus0_tx_wdata->name = "TX FIFO entry point for the abcdef DIMM bus";
    tx_fifo_waddr bus0_tx_waddr;
    rx_fifo_raddr bus0_rx_raddr;
    rx_byte_count bus0_rx_byte_count;
    rx_fifo_rdata bus0_rx_rdata;
    
    cmd bus1_cmd;
    bus1_cmd->name = "command for the ghijkl DIMM bus";
    tx_fifo_wdata bus1_tx_wdata;
    tx_fifo_waddr bus1_tx_waddr;
    bus1_tx_wdata->name = "TX FIFO entry point for the ghijkl DIMM bus";
    rx_fifo_raddr bus1_rx_raddr;
    rx_byte_count bus1_rx_byte_count;
    rx_fifo_rdata bus1_rx_rdata;
    
};