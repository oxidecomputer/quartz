// SystemRDL description of the sw-accessible registers in the SP5 sequencer
// block, shared by every SP5 board (cosmo, metro).
//
// The map is the union of what the boards need. The SP5 half is common. The
// NIC half differs by board -- cosmo carries a T6 behind a single reset, metro
// an AMD Versal with a rail per enable, boot straps and two PCIe channels --
// and both sets of NIC registers exist on both boards: the ones a board has no
// hardware for read as zero and their writes do nothing. Software should key
// off the board (the info block) before trusting a NIC register. Cosmo's
// layout is the original; everything metro added is appended or fills spare
// bits, so cosmo's offsets and bit positions have not moved.

addrmap sequencer_regs {
    name = "Power Sequencing Function";
    desc = "";

    default regwidth = 32;
    default sw = rw;
    default hw = r;
 
    // IRQ for faults
    reg irq {
        field {
            desc = "Fan Fault";
        } fanfault[1];
        field {
            desc = "Thermtrip- Thermal trip indicated from SP5 (sticky since fpga reset or last clear)";
        } thermtrip[1];
        field {
            desc = "SMERR_L asserted low while CPU was powered up";
        } smerr_assert[1];
        field {
            desc = "A1A0 MAPO- A fault in the A1-A0 domain(s) caused a MAPO (sticky since fpga reset or last clear)";
        } a0mapo[1];
        field {
            desc = "Nic MAPO- A fault in the NIC domain caused a MAPO (sticky since fpga reset or last clear)";
        } nicmapo[1];
        field {
            desc = "AMD PWROK falling edge while in >=A0 (sticky since fpga reset or last clear)";
        } amd_pwrok_fedge[1];
        field {
            desc = "AMD RESET falling edge while in >=A0 (sticky since fpga reset or last clear)";
        } amd_rstn_fedge[1];
        
        field {
            desc = "Live. Set '1' when smbus_fan_central_hsc_to_fpga1_alert_l is active (low on board)";
        } fan_central_hsc_alert[1];
        field {
            desc = "Live. Set '1' when smbus_fan_east_hsc_to_fpga1_alert_l is active (low on board)";
        } fan_east_hsc_alert[1];
        field {
            desc = "Live. Set '1' when smbus_fan_west_hsc_to_fpga1_alert_l is active (low on board)";
        } fan_west_hsc_alert[1];
        field {
            desc = "Live. Set '1' when smbus_ibc_to_fpga1_alert_l is active (low on board)";
        } ibc_alert[1];
        field {
            desc = "Live. Set '1' when smbus_m2_hsc_to_fpga1_alert_l is active (low on board)";
        } m2_hsc_alert[1];
        field {
            desc = "Live. Set '1' when smbus_nic_hsc_to_fpga1_alert_l is active (low on board)";
        } nic_hsc_alert[1];
        field {
            desc = "Live. Set '1' when smbus_v12_ddr5_abcdef_hsc_to_fpga1_alert_l is active (low on board)";
        } v12_ddr5_abcdef_hsc_alert[1];
        field {
            desc = "Live. Set '1' when smbus_v12_ddr5_ghijkl_hsc_to_fpga1_alert_l is active (low on board)";
        } v12_ddr5_ghijkl_hsc_alert[1];
        field {
            desc = "Live. Set '1' when smbus_v12_mcio_a0hp_hsc_to_fpga1_alert_l is active (low on board)";
        } v12_mcio_a0hp_hsc_alert[1];
        field {
            desc = "Live. Set '1' when main_hsc_to_fpga1_alert_l is active (low on board)";
        } main_hsc_alert[1];
        field {
            desc = "Live. Set '1' when vr_v1p8_sys_to_fpga1_alert_l is active (low on board)";
        } vr_v1p8_sys_to_fpga1_alert[1];
        field {
            desc = "Live. Set '1' when vr_v3p3_sys_to_fpga1_alert_l is active (low on board)";
        } vr_v3p3_sys_to_fpga1_alert[1];
        field {
            desc = "Live. Set '1' when vr_v5p0_sys_to_fpga1_alert_l is active (low on board)";
        } vr_v5p0_sys_to_fpga1_alert[1];
        field {
            desc = "Live. Set '1' when v0p96_nic_to_fpga1_alert_l is active (low on board). Cosmo only.";
        } v0p96_nic_to_fpga1_alert[1];
         field {
            desc = "Live. Set '1' when pwr_cont1_to_fpga1_alert_l is active (low on board).
This regulator controls VDDCR_CPU0_EN and VDDCR_SOC rails.";
        } pwr_cont1_to_fpga1_alert[1];
        field {
            desc = "Live. Set '1' when pwr_cont2_to_fpga1_alert_l is active (low on board)
This regulator controls VDDCR_CPU1_EN and VDDIO_SP5 rails.";
        } pwr_cont2_to_fpga1_alert[1];
        field {
            desc = "Live. Set '1' when pwr_cont3_to_fpga1_alert_l is active (low on board).
This regulator controls V1P1_SP5_A0, V1P8_SP5_A0 and V3P3_SP5_A0 rails.";
        } pwr_cont3_to_fpga1_alert[1];
         field {
            desc = "Live. Set '1' when pwr_cont4_to_fpga1_alert_l is active (low on board). Metro only.";
        } pwr_cont4_to_fpga1_alert[1];
        field {
            desc = "Live. Set '1' when the Versal is asserting ERROR_OUT. Metro only.";
        } versal_error_out[1];
        field {
            desc = "The pre-boot measurement of the NIC image failed (sticky since fpga reset or last clear). Metro only.";
        } nic_hash_err[1];
       };
    // Set up interrupt registers using a common irq_type
    irq IFR;
    IFR->name = "Interrupt Flag Register (W1C)";
    irq IER;
    IER->name = "Interrupt Enable Register";
    irq IGR;
    IGR->name = "Interrupt Generate Register self-clearing (W1S)";
    irq ILR;
    ILR->name = "Interrupt Live Register (read-only). Current 'raw' inputs to the IRQ block";

    reg {
        name = "Sequencer Status Register";
        default sw = r;
        
        field {
            desc = "Fan power OK";
        } fanpwrok[1] = 0;
         field {
            desc = "A0 power OK";
        } a0pwrok[1] = 0;
        field {
            desc = "NIC power OK";
        } nicpwrok[1] = 0;
        field {
            desc = "NIC has finished loading its image (Versal DONE). Metro only.";
        } nicdone[1] = 0;
        field {
            desc = "The last measurement of the NIC image produced a digest; it is in the
            hash engine's HW_DIGEST registers. Cleared when the next measurement starts.
            Metro only.";
        } nic_hash_done[1] = 0;
        field {
            desc = "The last measurement of the NIC image failed (see the hash engine's
            HW_STATUS) or was abandoned. Cleared when the next measurement starts.
            Metro only.";
        } nic_hash_err[1] = 0;
        field {
            desc = "Interrupt Pending Status (set if any enabled IRQ has its flag set)";
        } int_pend[31:31] = 0;
    } status;

    reg {
        name = "Fan Hotswap Control";
        field {
            desc = "Fan East hotswap disable";
        } fan_hsc_east_disable[1] = 0;
        field {
            desc = "Fan Central hotswap disable";
        } fan_hsc_central_disable[1] = 0;
         field {
            desc = "Fan West hotswap disable";
        } fan_hsc_west_disable[1] = 0;
    } early_power_ctrl;

    reg {
        default sw=r;
        field {
            desc = "Fan Fail: inversion of MAX31790ATI FAN_FAIL_N output (1=Fail asserted)";
        } fan_fail[1] = 0;
        field {
            desc = "Readback of fan East hotswap PG pin";
        } fan_hsc_east_pg[1] = 0;
        field {
            desc = "Readback of fan Central hotswap PG pin";
        } fan_hsc_central_pg[1] = 0;
         field {
            desc = "Readback of fan West hotswap PG pin";
        } fan_hsc_west_pg[1] = 0;
        field {
            desc = "Readback of fan East hotswap disable pin";
        } fan_hsc_east_disable[1] = 0;
        field {
            desc = "Readback of fan Central hotswap disable pin";
        } fan_hsc_central_disable[1] = 0;
         field {
            desc = "Readback of fan West hotswap disable pin";
        } fan_hsc_west_disable[1] = 0;
    } early_power_rdbks;
    
    reg {
        name = "Power Sequence Control";
        field {
            desc = "A0 Group power enable (starts state machine). 
            Note, no discrete A1 state control, it's a transitory state on the way to A0.
            Set to '1' to start the A2->A0/HP sequence. Set to '0' to disable, power off.
            Note that for fault cases, sw must clear and re-enable this bit as the state
            machine only enables in response to rising edge changes.";
        } a0_en[1] = 0;
    } power_ctrl;

    reg {
        name = "A0 Sequence Status";
        desc = "A0 'live' hubris 'api' state machine status. This is a stable api-like interface
        over the actual state machine implementation. The internal representation has additional, 
        implementation specific states and may change over time as we discover new things. See the 'raw'
        register for the full-fidelity view of the state machine.";
        default sw = r;

         enum seq_state_machine {
            IDLE = 8'h00 {desc = "";};
            ENABLE_GRP_A = 8'h01 {desc = "";};
            SP5_EARLY_CHECKPOINT = 8'h02 {desc = "";};
            ENABLE_GRP_B = 8'h03 {desc = "";};
            ENABLE_GRP_C = 8'h04 {desc = "";};
            POWER_GOOD = 8'h05 {desc = "";};
            SP5_FINAL_CHECKPOINT = 8'h08 {desc = "";};
            DONE = 8'h09 {desc = "";};
            DISABLING = 8'h0a {desc = "";};
            FAULTED = 8'h0b {desc = "";};
        };

        field {
            desc = "Sequencer Status";
            encode = seq_state_machine;
        } a0_sm[7:0];
    } seq_api_status;

     reg {
        name = "A0 Sequence Raw Status";
        desc = "This is an encoded view of the actual hw state machine. Here for debugging
        but not for general use. See the 'api' register for the 'stable' view of the state machine.
        Decode is implementation-defined, and may change as the FPGA implementation changes. See
        your friendly hw engineer for a true decode if needed.";
        default sw = r;

        enum a0_hw_state_machine {
                IDLE = 8'h00 {desc = "";};
                DDR_BULK_EN = 8'h01 {desc = "";};
                GROUP_A_EN = 8'h02 {desc = "";};
                GROUP_A_PG_AND_WAIT = 8'h03 {desc = "";};
                RSM_RST_DEASSERT = 8'h04 {desc = "";};
                RTC_CLK_WAIT = 8'h05 {desc = "";}; // PBTN low for 20ms
                SLP_CHECKPOINT = 8'h06 {desc = "";};
                GROUP_B_EN = 8'h07 {desc = "";};
                GROUP_B_PG_AND_WAIT = 8'h08 {desc = "";};
                GROUP_C_EN = 8'h09 {desc = "";};
                GROUP_C_PG_AND_WAIT = 8'h0a {desc = "";};
                ASSERT_PWRGOOD = 8'h0b {desc = "";};
                WAIT_PWROK = 8'h0c {desc = "";};
                WAIT_RESET_L_RELEASE = 8'h0d {desc = "";};
                DONE = 8'h0e {desc = "";};
                SAFE_DISABLE = 8'h0f {desc = "";};
        };

        field {
            desc = "Sequencer Raw Status";
            encode = a0_hw_state_machine;
        } hw_sm[7:0];
    } seq_raw_status;
    
    reg {
        name = "Nic SM Status";
        desc = "Nic 'live' hubris 'api' state machine status.This is a stable api-like interface
        over the actual state machine implementation. The internal representation has additional, 
        implementation specific states and may change over time as we discover new things. See the 'raw'
        register for the full-fidelity view of the state machine.";
        default sw = r;

        enum nic_state_machine {
            IDLE = 8'h00 {desc = "";};
            ENABLE_POWER = 8'h01 {desc = "";};
            NIC_RESET = 8'h02 {desc = "Rails are up, NIC held in reset (on metro: while the boot mode is strapped)";};
            DONE = 8'h03 {desc = "";};
            BOOTING = 8'h04 {desc = "Metro only. POR_B released, waiting for DONE";};
            MEASURING = 8'h05 {desc = "Metro only. Rails are up, holding POR_B while the hash engine measures the boot image";};
            DISABLE_POWER = 8'h06 {desc = "Metro only. POR_B asserted, rails being taken down in reverse order";};
            WAIT_SP5 = 8'h07 {desc = "Metro only. Rails up and the image measured, POR_B held; waiting for the SP5 to set mission_mode_en over eSPI1 before the Versal is configured. The boot flash is with the SP5 over eSPI1";};
            BOOT_FAILED = 8'h08 {desc = "Metro only. The Versal asserted ERROR_OUT or did not assert DONE within the host's timeout. POR_B asserted and the boot flash handed back to the SP5 over eSPI1 for reflash; clearing and setting mission_mode_en retries";};
         };
        field {
            desc = "Nic SM Status";
            encode = nic_state_machine;
        } nic_sm[7:0];
    } nic_api_status;

    reg {
        name = "NIC Sequence Raw Status";
        desc = "This is an encoded view of the actual hw state machine. Here for debugging
        but not for general use. See the 'api' register for the 'stable' view of the state machine.
        Decode is implementation-defined, and may change as the FPGA implementation changes. See
        your friendly hw engineer for a true decode if needed.";
        default sw = r;

        enum  nic_hw_state_machine {
            // In sequence order for each NIC, with DONE next to last and
            // POWER_DOWN last, so the max-hold of this register reads as
            // how far a power-up got.
            IDLE = 8'h00 {desc = "";};
            PWR_EN = 8'h01 {desc = "Cosmo (T6).";};
            WAIT_FOR_PGS = 8'h02 {desc = "Cosmo (T6).";};
            EARLY_CLD_RST = 8'h03 {desc = "Cosmo (T6).";};
            EARLY_PERST = 8'h04 {desc = "Cosmo (T6).";};
            EARLY_PERST_ASSERT = 8'h05 {desc = "Cosmo (T6).";};
            HSC_EN = 8'h06 {desc = "Metro (Versal). 12V hotswap enabled, waiting for 12V and 5V";};
            GROUP_1 = 8'h07 {desc = "Metro (Versal). Group 1, V3P3 and V1P8, enabled, waiting for PG";};
            GROUP_2 = 8'h08 {desc = "Metro (Versal). Group 2, V0P88, enabled, waiting for PG";};
            GROUP_3 = 8'h09 {desc = "Metro (Versal). Group 3, V0P8 VCCINT, enabled, waiting for PG";};
            GROUP_4 = 8'h0a {desc = "Metro (Versal). Group 4, V1P5 VCCAUX, enabled, waiting for PG";};
            GROUP_5 = 8'h0b {desc = "Metro (Versal). Group 5, V0P92 GTM/GTY AVCC, enabled, waiting for PG";};
            GROUP_6 = 8'h0c {desc = "Metro (Versal). Group 6, V1P5 AVCCAUX, enabled, waiting for PG";};
            GROUP_7 = 8'h0d {desc = "Metro (Versal). Group 7, V1P2 GTM/GTY AVTT, enabled, waiting for PG";};
            RAILS_SETTLE = 8'h0e {desc = "Metro (Versal). All rails good, holding POR_B while they settle";};
            HASH_WAIT = 8'h0f {desc = "Metro (Versal). Rails up and settled, POR_B held; waiting for the image measurement to finish, see nic_hash_status. Passed straight through with no measurement in flight or with versal_boot_ctrl.interlock_bypass set";};
            SP5_INTERLOCK = 8'h10 {desc = "Metro (Versal). Rails up, image measured, POR_B held; waiting for the SP5 to set mission_mode_en over eSPI1 (or versal_boot_ctrl.interlock_bypass). The flash is with eSPI1, no presence is shown. Also where a Versal parks when mission_mode_en is cleared";};
            MODE_STRAP = 8'h11 {desc = "Metro (Versal). Boot mode driven onto MODE[3:0], buffer enabled";};
            POR_RELEASE = 8'h12 {desc = "Metro (Versal). POR_B released";};
            WAIT_DONE = 8'h13 {desc = "Metro (Versal). Waiting for the Versal to assert DONE";};
            BOOT_FAILED = 8'h14 {desc = "Metro (Versal). ERROR_OUT, or no DONE within the host's nic_config_timeout. POR_B asserted and the flash back with eSPI1 for reflash; clearing mission_mode_en returns to SP5_INTERLOCK for another go";};
            DONE = 8'h15 {desc = "Booted. On metro the boot flash mux stays with the FPGA so the SP5 can reach it over eSPI";};
            POWER_DOWN = 8'h16 {desc = "Metro (Versal). POR_B asserted, rail groups being disabled in reverse order";};
        };

        field {
            desc = "NIC Sequencer Raw Status";
            encode = nic_hw_state_machine;
        } hw_sm[7:0];
    } nic_raw_status;


     reg {
        default sw=rw;
        default onwrite=wclr;
        field {
            desc = "Falling edge counter of AMD's reset output while in A0/A0HP. Saturates at 255. Cleared by any write or starting a new power up";
        } counts[7:0] = 0;
    } amd_reset_fedges;

    reg  {
        default sw=rw;
        default onwrite=wclr;
        field {
            desc = "Falling edge counter of AMD's PowerOK output while in A0/A0HP. Saturates at 255.  Cleared by any write or starting a new power up";
        } counts[7:0] = 0;
    } amd_pwrok_fedges;

     reg  {
        default sw=rw;
        default onwrite=wclr;
        field {
            desc = "Falling edge counter of AMD's PowerGDOUT output while in A0/A0HP. Saturates at 255.  Cleared by any write or starting a new power up";
        } counts[7:0] = 0;
    } amd_pwgdout_fedges;

   // input/output readbacks on all the enables powers for A1/A0/NIC
   // We build these up with the earliest supplies being the lowest order 
   // bits so that max-hold can be done and will make sense to see the most supplies that sequenced up.
   reg rails #(accesstype sw_kind = r) {
        default sw=sw_kind;

        field {
            desc = "DDR ABCDEF Hot Swap 12V controller";
        } abcdef_hsc[1];
        field {
            desc = "DDR GHIJKL Hot Swap 12V controller";
        } ghijkl_hsc[1];
        field {
            desc = "Group A V1p5 RTC 1.5V";
        } v1p5_rtc[1];
        field {
            desc = "Group A rail V3p3 SP5";
        } v3p3_sp5[1];
        field {
            desc = "Group A rail V1p8 SP5";
        } v1p8_sp5[1];
        field {
            desc = "Group B rail V1p1 SP5";
        } v1p1_sp5[1];
        field {
            desc = "Group C VDDIO SP5";
        } vddio_sp5[1];
        field {
            desc = "Group C VDDCR CPU1";
        } vddcr_cpu1[1];
        field {
            desc = "Group C VDDCR CPU0";
        } vddcr_cpu0[1];
        field {
            desc = "Group C VDDCR SOC";
        } vddcr_soc[1];
        field {
            desc = "NIC nic_hsc_12v (discrete pg, shared enable with 5V). On metro, enabled and checked ahead of group 1";
        } nic_hsc_12v[1];
        field {
            desc = "NIC nic_hsc_5v (discrete pg, shared enable with 12V). On metro, enabled and checked ahead of group 1";
        } nic_hsc_5v[1];
        field {
            desc = "Cosmo only. NIC v1p5_nic_a0hp (discrete pg, enable cascade from nic 5V)";
        } v1p5_nic_a0hp[1];
        field {
            desc = "Cosmo only. NIC v1p2_nic_pcie_a0hp (discrete pg, enable cascade from nic 5V)";
        } v1p2_nic_pcie_a0hp[1];
        field {
            desc = "Cosmo only. NIC v1p2_nic_enet_a0hp (discrete pg, enable cascade from nic 5V)";
        } v1p2_nic_enet_a0hp[1];
        field {
            desc = "Cosmo only. NIC v3p3_nic_a0hp (discrete pg, enable cascade from nic 5V)";
        } v3p3_nic_a0hp[1];
        field {
            desc = "Cosmo only. NIC v1p1_nic_a0hp (discrete pg, enable cascade from nic 5V)";
        } v1p1_nic_a0hp[1];
        field {
            desc = "Cosmo only. NIC v1p4_nic_a0hp (discrete pg, enable cascade from nic 5V). Note: mirrors enable on HCV A boards, actual pin readback on HCV B and newer boards";
        } v1p4_nic_a0hp[1];
        field {
            desc = "Cosmo only. NIC v0p96_nic_vdd_a0hp (discrete pg, enable cascade from nic 5V)";
        } v0p96_nic_vdd_a0hp[1];
        // Metro's Versal rail tree. Its hotswaps share the nic_hsc_* bits above.
        // The group is the versal_seq rail group the rail is enabled in and whose
        // power good check it is part of.
        field {
            desc = "Metro only. Versal VCCINT 0.8V. Group 3";
        } versal_v0p8_vccint[1];
        field {
            desc = "Metro only. Versal 0.88V. Group 2";
        } versal_v0p88[1];
        field {
            desc = "Metro only. Versal transceiver AVCC 0.92V. Group 5 (discrete pg, no enable of its own; comes up with V1P1)";
        } versal_v0p92_avcc[1];
        field {
            desc = "Metro only. Versal 1.1V. Group 5 (enable only; no pg pin, reads back its enable)";
        } versal_v1p1[1];
        field {
            desc = "Metro only. Versal transceiver AVTT 1.2V. Group 7 (discrete pg, no enable of its own; comes up with V1P4)";
        } versal_v1p2_avtt[1];
        field {
            desc = "Metro only. Versal 1.4V. Group 7 (enable only; no pg pin, reads back its enable)";
        } versal_v1p4[1];
        field {
            desc = "Metro only. Versal VCCAUX 1.5V. Group 4";
        } versal_v1p5[1];
        field {
            desc = "Metro only. Versal transceiver AVCCAUX 1.5V. Group 6";
        } versal_v1p5_avccaux[1];
        field {
            desc = "Metro only. Versal VCCO 1.8V. Group 1";
        } versal_v1p8[1];
        field {
            desc = "Metro only. Versal VCCO 3.3V. Group 1";
        } versal_v3p3[1];
    };

    rails #(.sw_kind(rw)) rail_enables ;
    rail_enables->name = "Rail Enable Readbacks. (Out from FPGA)"; 

    rails rail_pgs;
    rail_pgs->name = "Rail Power Good status (live). (Inputs to FPGA). A NIC rail the board does not have reads as good, so anything but all ones in the NIC bits is a real rail"; 

    rails #(.sw_kind(rw)) rail_pgs_max_hold;
    rail_pgs_max_hold->name = "Rail Power Good status (max hold). (Inputs to FPGA). Write clears, or sequence up clears";

    reg {
        name = "SP5 signal readbacks";
        desc = "Live status and readbacks of our registers and responses back from the SP5
        For tri-state cases, read '1' as 'Z'.  No inversions done here.";
        default sw = r;
        field {
            desc = "SMERR_L live status, note: only valid when SP5 rails are up (From SP5)";
        } smerr_l[1];
        field {
            desc = "Thermtrip_l live status, note: only valid when SP5 rails are up (From SP5)";
        } thermtrip_l[1];
        field {
            desc = "reset_l live status, note: only valid when SP5 rails are up (From SP5)";
        } reset_l[1];
        field {
            desc = "pwr_ok live status, note: only meaningful when SP5 rails are up (From SP5)";
        } pwr_ok[1];
        field {
            desc = "slp_s3_l live status, note: only valid when SP5 rails are up (or being sequenced up) (From SP5)";
        } slp_s3_l[1];
        field {
            desc = "slp_s5_l live status, note: only valid when SP5 rails are up (or being sequenced up) (From SP5)";
        } slp_s5_l[1];
        field {
            desc = "rsmrst_l live status, (From FPGA to SP5)";
        } rsmrst_l[1];
        field {
            desc = "pwr_btn_l live status, (From FPGA to SP5)";
        } pwr_btn_l[1];
        field {
            desc = "pwr_btn_l live status, (From FPGA to SP5)";
        } pwr_good[1];
         field {
            desc = "pwrgd_out live status, (From SP5 to FPGA)";
        } pwrgd_out[1];
        
    } sp5_readbacks;

    reg {
        name = "Nic-related signal readbacks";
        desc = "Cosmo only; metro reads zeros here and has versal_readbacks instead.
        Live status and readbacks of our registers and responses back from the NIC
        (and SP5 for MFG-mode)
        For tri-state cases, read '1' as 'Z'.  No inversions done here.";
        default sw = r;
        field {
            desc = "Cosmo only. cld_rst_l live status, (From FPGA to NIC)";
        } cld_rst_l[1];
        field {
            desc = "Cosmo only. perst_l live status, (From FPGA to NIC)";
        } perst_l[1];
        field {
            desc = "Cosmo only. nic_mfg_mode_l live status, (From FPGA to NIC)";
        } nic_mfg_mode_l[1];
        field {
            desc = "Cosmo only. eeprom_wp_l live status, note: only valid when SP5 rails are up (From FPGA to eeprom)";
        } eeprom_wp_l[1];
        field {
            desc = "Cosmo only. eeprom_wp_buffer_oe_l live status, note: only valid when SP5 rails are up (From FPGA to buffer)";
        } eeprom_wp_buffer_oe_l[1];
        field {
            desc = "Cosmo only. flash_wp_l live status, note: only valid when SP5 rails are up (From FPGA to flash)";
        } flash_wp_l[1];
        field {
            desc = "Cosmo only. nic_pcie_clk_buff_oe_l live status, note: only valid when SP5 rails are up (From FPGA to buffer)";
        } nic_pcie_clk_buff_oe_l[1];
        field {
            desc = "Cosmo only. ext_rst_l live status, note: only valid when NIC rails are up (From NIC)";
        } ext_rst_l[1];
        field {
            desc = "Cosmo only. sp5_mfg_mode_l live status, (From SP5 to FPGA)";
        } sp5_mfg_mode_l[1];
        field {
            desc = "Cosmo only. sp5_perst_l live status, (From SP5 hotplug to FPGA)";
        } sp5_perst_l[1];
    } nic_readbacks;

    reg {
        name = "Debug  enable";
        desc = "Allow manual control over some I/O ping for debugging purposes";
        field {
            desc = "Ignore sp5 allows the sequencer to bypass any SP5-related handshakes
            for power debugging. Some rails may not completely power up without a load-slammer
            or other feedback device in place.
            While set, neither A0 nor the NIC MAPOs: a rail fault, upstream loss or
            nic_test_mapo leaves everything enabled and raises no A0MAPO/NICMAPO interrupt,
            and is recorded in mapo_suppressed instead. Metro's POR_B stays interlocked with
            the Versal rails. Clearing the bit with a fault still present MAPOs at once.";
        } ignore_sp5[1] = 0;
         field {
            desc = "Set to mux in the nic_override signals instead of the normal nic control signals";
        } nic_override[1] = 0;
        field {
            desc = "Used for manually controlling the nic reset for debugging purposes";
        } force_nic_reset[1] = 0;
        field {
            desc = "Cosmo only. Let other logic run but directly force mfg mode_l to be asserted when set";
        } force_mfg_mode[1] = 0;
        field {
            desc = "Hold the NIC (A0HP) sequencer off while leaving A0 alone. While set, a0_en does
            not reach the NIC sequencer and a PERST de-assertion from the SP5 does not restart
            it after a fault. Setting it with the NIC up powers the NIC down as a software
            disable would, without a fault. Clearing it while a0_en is set starts the NIC sequence.";
        } a0hp_inhibit[1] = 0;
    } debug_enables;

    reg {
        name = "Nic Overrides";
        desc = "Control over the nic signals for debugging purposes outside the sequencer logic.
        Cosmo only, apart from nic_test_mapo; metro has versal_overrides instead.";
        field {
            desc = "Cosmo only. cld_rst_l live status, (From FPGA to NIC)";
        } cld_rst_l[1] = 0;
        field {
            desc = "Cosmo only. perst_l live status, (From FPGA to NIC)";
        } perst_l[1] = 0;
        field {
            desc = "Cosmo only. nic_mfg_mode_l live status, (From FPGA to NIC)";
        } nic_mfg_mode_l[1] = 0;
        field {
            desc = "Cosmo only. eeprom_wp_l live status, note: only valid when SP5 rails are up (From FPGA to eeprom)";
        } eeprom_wp_l[1] = 0;
        field {
            desc = "Cosmo only. eeprom_wp_buffer_oe_l live status, note: only valid when SP5 rails are up (From FPGA to buffer)";
        } eeprom_wp_buffer_oe_l[1] = 1;
        field {
            desc = "Cosmo only. flash_wp_l live status, note: only valid when SP5 rails are up (From FPGA to flash)";
        } flash_wp_l[1] = 0;
        field {
            desc = "Cosmo only. nic_pcie_clk_buff_oe_l live status, note: only valid when SP5 rails are up (From FPGA to buffer)";
        } nic_pcie_clk_buff_oe_l[1] = 1;
        field {
            desc = "Self-clearing. Set to 1 to trigger a NIC-domain MAPO for testing purposes. Both boards.";
        } nic_test_mapo[1] = 1;
    } nic_overrides;

    rails #(.sw_kind(rw)) rail_masks ;
    rail_masks->name = "Rail PG masks. Set to '1' to prevent the sequencer from seeing a particular rail's PG as 'good' for testing purposes."; 

    reg {
        name = "SP5 sequencer Test Masks";
        desc = "Set corresponding bit to 1 to mask off a particular signal from asserting during sequencing to test sequencing behavior in the presense of 'faults'.";
        field {
            desc = "Setting this bit makes the sequencer never see fan East hotswap PG pin active";
        } fan_hsc_east_pg[1] = 0;
        field {
            desc = "Setting this bit makes the sequencer never see fan Central hotswap PG pin active";
        } fan_hsc_central_pg[1] = 0;
         field {
            desc = "Setting this bit makes the sequencer never see fan West hotswap PG pin active";
        } fan_hsc_west_pg[1] = 0;
        field {
            desc = "Setting this bit makes the sequencer never see pwr_ok.";
        } pwr_ok_msk[1];
        field {
            desc = "Setting this bit to '1' makes the sequencer never see slp_s3_l assert, to test behavior when this signal is not asserted by SP5 during sequencing.";
        } slp_s3_l_msk[1];
        field {
            desc = "Setting this bit to '1' makes the sequencer never see slp_s5_l assert, to test behavior when this signal is not asserted by SP5 during sequencing.";
        } slp_s5_l_msk[1];
    } sp5_seq_test_mask;

     reg {
        name = "ignition flash and reconfig control";
        desc = "For debugging purposes, allows the sequencer to write to the ignition flash and reconfigure it. Turning this mux on isolates the front FPGA my muxing away from it";
        field {
            desc = "Ignition reconfigure trigger. This latches on once set since ignition should powercycle the IBC. Setting this bit results in an SP power-cycle";
        } ignition_creset[1:1] = 0;
        field {
            desc = "Set to 1 to isolate front FPGA and be connected to ignition flash instead";
        } mux_to_ignition[0:0] = 0;
    } ignition_control;
    
    reg {
        name = "PCIe Backplane Clock Control";
        desc = "Control over the PCIe backplane clock. Normally we use SRIS on this interface in the rack, but for
        minibar configs we need to drive a clock. Allow Hubris to control whether this clock is driven when something
        is attached.";

        field {
            desc = "Enable the PCIe backplane clock. (Still gated by presence)";
        } clk_en[0:0] = 0;
    } pcie_clk_ctrl;

    // Everything below is metro's Versal NIC. Cosmo reads zeros here.

    reg {
        name = "Versal-related signal readbacks";
        desc = "Metro only. Live status and readbacks of our registers and responses back from the Versal.
        For tri-state cases, read '1' as 'Z'.  No inversions done here.";
        default sw = r;
        field {
            desc = "POR_B live status, (From FPGA to Versal)";
        } por_b[1];
        field {
            desc = "MODE[3:0] live status, (From FPGA to Versal)";
        } mode[4];
        field {
            desc = "mode_buffer_en_l live status, (From FPGA to the MODE buffer)";
        } mode_buffer_en_l[1];
        field {
            desc = "err_done_buff_en live status, (From FPGA to the DONE/ERROR_OUT buffer)";
        } err_done_buff_en[1];
        field {
            desc = "DONE live status, note: only valid once err_done_buff_en is set (From Versal)";
        } done[1];
        field {
            desc = "ERROR_OUT live status, note: only valid once err_done_buff_en is set (From Versal)";
        } error_out[1];
        field {
            desc = "Channel A perst_l live status, (From FPGA to Versal)";
        } cha_perst_l[1];
        field {
            desc = "Channel A prsnt_l live status, (From Versal)";
        } cha_prsnt_l[1];
        field {
            desc = "Channel A pwren_l live status, (From Versal)";
        } cha_pwren_l[1];
        field {
            desc = "Channel A clk_buff_oe_l live status, (From FPGA to buffer)";
        } cha_clk_buff_oe_l[1];
        field {
            desc = "Channel B perst_l live status, (From FPGA to Versal)";
        } chb_perst_l[1];
        field {
            desc = "Channel B prsnt_l live status, (From Versal)";
        } chb_prsnt_l[1];
        field {
            desc = "Channel B pwren_l live status, (From Versal)";
        } chb_pwren_l[1];
        field {
            desc = "Channel B clk_buff_oe_l live status, (From FPGA to buffer)";
        } chb_clk_buff_oe_l[1];
        field {
            desc = "Channel A slot sp5_perst_l live status, (From SP5 hotplug to FPGA)";
        } sp5_cha_perst_l[1];
        field {
            desc = "Channel B slot sp5_perst_l live status, (From SP5 hotplug to FPGA)";
        } sp5_chb_perst_l[1];
    } versal_readbacks;

    reg {
        name = "Versal Overrides";
        desc = "Metro only. Control over the Versal signals for debugging purposes outside the
        sequencer logic, muxed in by debug_enables.nic_override. A test MAPO is raised
        through nic_overrides.nic_test_mapo as on cosmo.";
        field {
            desc = "por_b drive, (From FPGA to Versal)";
        } por_b[1] = 0;
        field {
            desc = "mode_buffer_en_l drive, (From FPGA to the MODE buffer)";
        } mode_buffer_en_l[1] = 1;
        field {
            desc = "err_done_buff_en drive, (From FPGA to the DONE/ERROR_OUT buffer)";
        } err_done_buff_en[1] = 0;
        field {
            desc = "Channel A perst_l drive, (From FPGA to Versal)";
        } cha_perst_l[1] = 0;
        field {
            desc = "Channel A clk_buff_oe_l drive, (From FPGA to buffer)";
        } cha_clk_buff_oe_l[1] = 1;
        field {
            desc = "Channel B perst_l drive, (From FPGA to Versal)";
        } chb_perst_l[1] = 0;
        field {
            desc = "Channel B clk_buff_oe_l drive, (From FPGA to buffer)";
        } chb_clk_buff_oe_l[1] = 1;
    } versal_overrides;

    reg {
        name = "Versal Boot Control";
        desc = "Metro only. How the Versal gets configured. By default the NIC power sequence
        measures the boot image (hash engine, range from HW_FLASH_ADDR/HW_LENGTH) while the
        rails come up, then holds POR_B at SP5_INTERLOCK until the SP5, having read the
        digest over eSPI1, sets mission_mode_en in eSPI1's platform registers. Without
        host software that does this the NIC sits at SP5_INTERLOCK until interlock_bypass
        is set.";
        field {
            desc = "Versal boot mode driven onto MODE[3:0]. 0x0 is JTAG, 0x2 is QSPI32, which
            is how the board is wired. JTAG is the escape hatch for bring-up. Latched as the
            sequencer leaves SP5_INTERLOCK, so it can be changed while the NIC waits there.";
        } mode[3:0] = 4'h2;
        field {
            desc = "Skip the image measurement and the SP5 interlock: the power sequence starts
            no measurement and POR_B releases as soon as the rails have settled, with or
            without mission_mode_en. Bench use; off by default.";
        } interlock_bypass[4:4] = 0;
        field {
            desc = "Self-clearing. Set to 1 to start a measurement now. Taken as soon as the
            flash is on the FPGA side (any time the Versal is not being configured);
            until then it waits, see nic_hash_status.pending.";
        } hash_start[5:5] = 0;
    } versal_boot_ctrl;

    reg {
        name = "NIC image measurement status";
        desc = "Metro only. The state machine that has the hash engine measure the NIC's boot
        image. It runs on its own, alongside the NIC power sequence, whenever the flash is on
        the FPGA side; the digest is in the hash engine's HW_DIGEST registers and, for the
        SP5, in eSPI1's platform registers.";
        default sw = r;

        enum nic_hash_state_machine {
            IDLE = 8'h00 {desc = "No measurement in flight";};
            RUNNING = 8'h01 {desc = "Request made of the hash engine, waiting for its acknowledge";};
            ACK_RELEASE = 8'h02 {desc = "Acknowledged, waiting for the hash engine to drop its acknowledge";};
        };
        field {
            desc = "Measurement state machine";
            encode = nic_hash_state_machine;
        } hash_sm[7:0];
        field {
            desc = "The last measurement finished and produced a digest. Cleared when the next one starts.";
        } done[8:8];
        field {
            desc = "The last measurement finished without a usable digest: the hash engine reported
            an error, or the measurement was abandoned. Cleared when the next one starts.";
        } err[9:9];
        field {
            desc = "POR_B was released with the measurement in flight, so the flash went to the NIC
            part way through it. Cleared when the next one starts.";
        } abandoned[10:10];
        field {
            desc = "The current or last measurement was started by versal_boot_ctrl.hash_start.";
        } sw_started[11:11];
        field {
            desc = "A start is waiting: for the flash to come back to the FPGA once the Versal
            has been configured, or for the measurement in flight to finish.";
        } pending[12:12];
        field {
            desc = "The current or last measurement was started by the SP5 over eSPI1.";
        } host_started[13:13];
    } nic_hash_status;

    reg {
        name = "Board Version";
        desc = "Metro only. Board version straps read directly off the FPGA1_VERSION_ID pins.";
        default sw = r;
        field {
            desc = "FPGA1_VERSION_ID[1:0] strap value";
        } version_id[1:0];
    } board_version;

    reg {
        name = "Suppressed MAPOs";
        desc = "Sticky record of MAPOs that debug_enables.ignore_sp5 kept from happening: the
        fault was seen, but power stayed up and no interrupt was raised. Write clears.
        While the fault lasts, rail_pgs shows which rail it is.";
        default sw = rw;
        field {
            desc = "A0 would have MAPO'd";
        } a0[0:0] = 0;
        field {
            desc = "The NIC (A0HP) would have MAPO'd";
        } nic[1:1] = 0;
    } mapo_suppressed;

};
   