// Copyright 2022 Oxide Computer Company
// This is SystemRDL description of the sw-accesible registers in the Gimlet
// Sequencer FPGA.

addrmap gimlet_seq_fpga {
    name = "Gimlet Sequencer FPGA";
    desc = "Register description of the Gimlet Sequencer FPGA";

    default regwidth = 8;
    default sw = rw;
    default hw = r;

    reg {
        name = "Identification 0";
        default sw = r;
        
        field {
            desc = "0x1";
        } data[7:0] =  0x01;

    } ID0;
    reg {
        name = "Identification 1";
        default sw = r;
         
        field {
            desc = "de";
        } data[7:0] = 0xde;
    } ID1;
    reg {
        name = "Version 0"; 
        default sw = r;

        field {
            desc = "version[31..24]";
        } data[7:0] = 0;
    } VER0;
    reg {
        name = "Version 1";
        default sw = r;

        field {
            desc = "version[23..16]";
        } data[7:0] = 0;
    } VER1;
    reg {
        name = "Version 2";
        default sw = r;

        field {
            desc = "version[15..8]";
        } data[7:0] = 0;
    } VER2;
    reg {
        name = "Version 3";
        default sw = r;

        field {
            desc = "version[7..0]";
        } data[7:0] = 0;
    } VER3;
    reg {
        name = "ShortSHA part 0";
        default sw = r;

        field {
            desc = "sha[31..24]";
        } data[7:0] = 0;
    } SHA0;
    reg {
        name = "ShortSHA part 1";
        default sw = r;

        field {
            desc = "sha[23..16]";
        } data[7:0] = 0;
    } SHA1;
    reg {
        name = "ShortSHA part 2";
        default sw = r;

        field {
            desc = "sha[15..8]";
        } data[7:0] = 0;
    } SHA2;
    reg {
        name = "ShortSHA part 3";
        default sw = r;
        field {
            desc = "sha[7..0]";
        } data[7:0] = 0;
    } SHA3;
    reg {
        name = "FPGA Checksum0";
        field {
            desc = "Scribble Register for read-write use";
        } CS0[7:0] = 0;
    } CS0;
    reg {
        name = "FPGA Checksum1";
        field {
            desc = "Scribble Register for read-write use";
        } CS1[7:0] = 0;
    } CS1;
    reg {
        name = "FPGA Checksum2";
        field {
            desc = "Scribble Register for read-write use";
        } CS2[7:0] = 0;
    } CS2;
    reg {
        name = "FPGA Checksum3";
        field {
            desc = "Scribble Register for read-write use";
        } CS3[7:0] = 0;
    } CS3;
    reg {
        name = "Scratchpad";

        field {
            desc = "Scribble Register for read-write use";
        } TBD[7:0] = 0;
    } SCRTCHPAD;

    reg irq_type {
        field {
            desc = "Fan Fault";
        } FANFAULT[1];
        field {
            desc = "Thermtrip";
        } THERMTRIP[1];
        field {
            desc = "A1 MAPO";
        } A1MAPO[1];
        field {
            desc = "A0 MAPO";
        } A0MAPO[1];
        field {
            desc = "Nic MAPO";
        } NICMAPO[1];
        field {
            desc = "AMD PWROK fedge while in >=A0";
        } AMD_PWROK_FEDGE[1];
        field {
            desc = "AMD RESET fedge while in >=A0";
        } AMD_RSTN_FEDGE[1];
    };

    // Set up interrupt registers using a common irq_type
    irq_type IFR;
    IFR->name = "Interrupt Flag Register"; 
    irq_type IER;
    IER->name = "Interrupt Enable Register";

    reg {
        name = "Sequencer Status Register";
        default sw = r;
        
        field {
            desc = "Fan power OK";
        } FANPWROK[1] = 0;
        field {
            desc = "A1 power OK";
        } A1PWROK[1] = 0;
         field {
            desc = "A0 power OK";
        } A0PWROK[1] = 0;
        field {
            desc = "NIC power OK";
        } NICPWROK[1] = 0;
        field {
            desc = "Interrupt Pending Status";
        } INT_PEND[7:7] = 0;
    } STATUS;

    reg early_power {
        field {
            desc = "Fan power enable";
        } FANPWREN[1] = 0;
        field {
            desc = "Enables V2P5_DIMM_ABCD_SPD_A0 rail (SEQ_TO_DIMM_ABCD_V2P5_EN net).";
        } ABCD_SPD_EN[1] = 0;
        field {
            desc = "Enables V2P5_DIMM_EFGH_SPD_A0 rail. (SEQ_TO_DIMM_EFGH_V2P5_EN net).";
        } EFGH_SPD_EN[1] = 0;
        field {
            desc = "External pull-up give SP control of restarting. 
            Falling edge triggers restart function which tags 2-25sec 
            (default 10s) set by PMBus registers. 10us glitch filter at ADM1272.
            Writing to this will cause a strobe that exceeds the glitch filter
            timing and will self-clear (note actual output is inverted to meet
            circuit's active low requirement";
            singlepulse = true;
        } FANHP_RESTART[7:7] = 0;
    };

    early_power EARLY_POWER_CTRL;
    EARLY_POWER_CTRL->name = "Early Power Control Register";
    
    reg {
        name = "Power Sequence Control";
        field {
            desc = "A1 power enable (starts state machine)";
        } A1PWREN[1] = 0;
        field {
            desc = "A0 Group power enable (starts state machine)";
        } A0A_EN[1] = 0;
    } PWR_CTRL;
    reg {
        name = "T6 NIC Control";
        field {
            desc = "NIC CLD_RST control. Controls CLD_RST_N (inverted). Defaults to reset asserted to be
            cleared by software when SP3 hotplug indicates enable";
        } CLD_RST[1] = 1;

    } NIC_CTRL;
    reg {
        name = "A1 SM Status";
        desc = "A1 'live' state machine status";
        default sw = r;

        enum a1_state_machine {
            IDLE = 8'h00 {desc = "";};
            ENABLE = 8'h01 {desc = "";};
            WAITPG = 8'h02 {desc = "";};
            DELAY = 8'h03 {desc = "";};
            DONE = 8'h05 {desc = "";};
        };

        field {
            desc = "State Machine enum";
            encode = a1_state_machine;
        } A1SM[7:0];
    } A1SMSTATUS;

    reg a0_sm {
        name = "A0 SM Status";
        desc = "A0 'live' state machine status";
        default sw = r;

         enum a0_state_machine {
            IDLE = 8'h00 {desc = "";};
            PBTN = 8'h01 {desc = "";};
            WAITSLP = 8'h02 {desc = "";};
            GROUPB1_EN = 8'h03 {desc = "";};
            GROUPB1_PG = 8'h04 {desc = "";};
            GROUPB2_EN = 8'h05 {desc = "";};
            GROUPB2_PG = 8'h06 {desc = "";};
            GROUPC_PG = 8'h07 {desc = "";};
            DELAY_1MS = 8'h08 {desc = "";};
            ASSERT_PG = 8'h09 {desc = "";};
            WAIT_PWROK = 8'h0a {desc = "";};
            WAIT_RESET_L = 8'h0b {desc = "";};
            DONE = 8'h0c {desc = "";};
            SAFE_DISABLE = 8'h0d {desc = "";};
        };

        field {
            desc = "State Machine enum";
            encode = a0_state_machine;
        } A0SM[7:0];
    };
    a0_sm A0SMSTATUS;
    reg {
        name = "Nic SM Status";
        desc = "Nic 'live' state machine status";
        default sw = r;

        enum nic_state_machine {
            IDLE = 8'h00 {desc = "";};
            PS_PG = 8'h01 {desc = "";};
            PG_DELAY = 8'h02 {desc = "";};
            EARLY_RESET = 8'h03 {desc = "";};
            DONE = 8'h04 {desc = "";};
         };
        field {
            desc = "Nic SM Status";
            encode = nic_state_machine;
        } NicSM[7:0];
        // TODO: A1 state machine decode in here
    } NICSMSTATUS;
    reg {
        name = "Board Ver straps";
        desc = "3 bits of board version based on input straps";
        default sw = r;
        field {
            desc = "0x7 or 0x0 = A. 0x1 = B, 0x2 = C, 0x3 = D, 0x4 = E";
        } ID[2:0];
    } BOARD_REV;
    // Readback blocks:
    // These are built as contiguous registers so that a single multi-byte read 
    // could capture all of them.
    // Readbacks of pins for FAN-power related things
    reg {
        name = "Pre-A1 Power Readback Register";
        default sw = r;

        field {
            desc = "Input from ADM1272. Rising edge enable PMBus OPERATION on
            command or PMBus POWER_CYCLE required to clear, assuming all
            faults are clear. (Inverted to active high in register)";
        } FANHP_TO_SEQ_FAULT[1] = 0;
        field {
            desc = "From ADUM1272. Asserted when PWGIN > thresh, enable pin is
            high and UVx and OV pins are in-range, no actuive fault conditons 
            and mosfet is fully enhanced (Vgs > 10V).";
        } FANHP_TO_SEQ_PWRGD[1] = 0;
        field {
            desc = "Input from ADM1272. Rising edge enable PMBus OPERATION on 
            command or PMBus POWER_CYCLE required to clear, assuming all faults 
            are clear.";
        } FAN_TO_SEQ_FAN_FAIL[1] = 0;
        field {
            desc = "Readback for V2P5_DIMM_ABCD_SPD_A0 rail (DIMM_TO_SEQ_ABCD_V2P5_PG net)";

        } ABCD_V2P5_SPD_PG[1] = 0;
        field {
            desc = "Readback for V2P5_DIMM_EFGH_SPD_A0 rail (DIMM_TO_SEQ_EFGH_V2P5_PG net)";

        } EFGH_V2P5_SPD_PG[1] = 0;
    } EARLY_RBKS;

    // Readbacks of pins for A1-power related things
    reg {
        name = "A1 power readbacks";
        default sw = r;

        field {
            desc = "Readback for V1P5_SP_VDD_RTC_A1 rail.
            (SP3_TO_SEQ_RTC_V1P5_EN - a poor net name)";
        } V1P5_RTC_PG[1] = 0;

        field {
            desc = "Readback for V3P3_SP3_VDD_33_S5_A1 rail 
            (SP3_TO_SEQ_V3P3_S5_PG)";
        } V3P3_S5_PG[1] = 0;
        field {
            desc = "Readback for V1P8_SP3_VDD_18_S5_A rail 
            (SP3_TO_SEQ_V1P8_S5_PG)";
        } V1P8_S5_PG[1] = 0;
        field {
            desc = "Readback for V0P9_SP3_VDD_SOC_S5_A1 rail 
            (SP3_TO_SEQ_V0P9_VDD_SOC_S5_PG)";
        } V0P9_VDD_SOC_S5_PG[1] = 0;
    } A1_READBACKS;

    // Readbacks of pins for A0-power related things
    reg {
        name = "AMD readbacks for A0-signals";
        default sw = r;

        field {
            desc = "SP3_TO_SP_SLP_S3 inversion of signal from AMD CPU, Used
            at beginning of GroupB state machine";
        } SLP_S3[1] = 0;
        field {
            desc = "SP3_TO_SP_SLP_S5 inversion of signal from AMD CPU, Used 
            at beginning of GroupB state machine";
        } SLP_S5[1] = 0;
        field {
            desc = "Asserted by AMD after PWR_GOOD is asserted by sequencer 
            should be here in: min 15ms, max of 20.4ms(SP3_TO_SEQ_PWROK_V3P3 net)";
        } PWROK[1] = 0;
        field {
            desc = "Asserted (and inverted) from AMD's RESET_L pin. 10Ms minimum assertion time, 
            remains asserted for minimum of 1ms after PWROK assertion
            (SP3_TO_SEQ_RESET_V3P3_L net)";
        } RESET[1] = 0;
    } AMD_A0;

    reg Groupb_Pg{
        name = "A0 Power Goods for Group B supplies";
        default sw = r;

        field {
            desc = "Readback from VPP_ABCD_A0 rail (PWR_CONT_DIMM_ABCD_PG0 net)";
        } VPP_ABCD_PG[1] = 0;
        field {
            desc = "Readback from VPP_EFGH_A0 rail (PWR_CONT_DIMM_EFGH_PG0 net)";
        } VPP_EFGH_PG[1] = 0;
        field {
            desc = "Readback from VDD_MEM_ABCD_A0 rail (PWR_CONT1_SP3_PG1)
            Power good 1 for RA229618 (U350) is configured for 
            VDD_MEM_ABCD_A0";
        } VDD_MEM_ABCD_PG[1];
        field {
            desc = "Readback from VDD_MEM_EFGH_A0 rail (PWR_CONT2_SP3_PG1)
            Power good 1 for RA229618 (U351) is configured for 
            VDD_MEM_EFGH_A0";
        } VDD_MEM_EFGH_PG[1];
        field {
            desc = "Readback for VTT_ABCD_A0 rail (VTT_ABCD_A0_TO_SEQ_PG_L) inverted";
        } VTT_ABCD_PG[1];
        field {
            desc = "Readback for VTT_EFGH_A0 rail (VTT_EFGH_A0_TO_SEQ_PG_L) inverted";
        } VTT_EFGH_PG[1];
        field {
            desc = "Readback for V1P8_SP3_VDD_18_A0 rail (SEQ_V1P8_SP3_VDD_PG_L) inverted";
        } V1P8_SP3_PG[1];
        field {
            desc = "Readback from V3P3_SYS_A0 rail (PWR_CONT_DIMM_ABCD_PG1)
            PG1 from ISL68224 U352, should be configured to represent 
            V3P3_SYS_A0 rail status";
        } V3P3_SYS_PG[1] = 0;
    };
    Groupb_Pg GROUPB_PG;

    reg {
        name = "A0 Power Goods for Un-used supplies";
        default sw = r;

        field {
            desc = "From ISL68224 U352. PWR_CONT_DIMM_ABCD_PG2 net. No defined function.";
        } ABCD_PG2[1] = 0;

        field {
            desc = "From ISL68224 U418. PWR_CONT_DIMM_EFGH_PG1 net. No defined function.";
        } EFGH_PG1[1] = 0;

        field {
            desc = "From ISL68224 U418. PWR_CONT_DIMM_EFGH_PG2 net. No defined function.";
        } EFGH_PG2[1] = 0;
    } GROUPB_UNUSED;

    reg {
        name = "A0 Power Faults for Group B + C supplies";
        default sw = r;

        field {
            desc = "Set high (inverted from board) when rail reaches OT_WARN threshold, 
            only valid after configuration (PWR_CONT1_SP3_NVRHOT net).
            from RAA229618 U350 controlling SP3_VDD_VCORE_A0 and VDD_MEM_ABCD_A0 rails";
        } CONT1_NVRHOT[1] = 0;
        field {
            desc = "Catastrophic fault protection output from RAA229618 U350 controlling 
            SP3_VDD_VCORE_A0 and VDD_MEM_ABCD_A0 rails";
        } CONT1_CFP[1] = 0;
        field {
            desc = "Set high (inverted from board) when rail reaches OT_WARN threshold, only valid 
            after configuration. From RAA229618 U351 driving rails SP3_VDDCR_SOC_A0 and 
            VDD_MEM_EFGH_A0 (PWR_CONT2_SP3_NVRHOT net)";
        } CONT2_NVRHOT[1] = 0;
         field {
            desc = "Catastrophic fault protection output from RAA229618 U351 controlling 
            SP3_VDDCR_SOC_A0 and VDD_MEM_EFGH_A0 rails (PWR_CONT2_SP3_CFP net).";
        } CONT2_CFP[1] = 0;
    } GROUPBC_FLTS;

    reg Groupc_Pg {
        name = "A0 STATUS for Group C supplies";
        default sw = r;

        field {
            desc = "Power good 0 for RA229618 (U351) is configured for 
                    SP3_VDDCR_SOC_A0 (PWR_CONT2_SP3_PG0 net)";
        } VDDCR_SOC_PG[1] = 0;
        field {
            desc = "Power good 0 from RA229618 (U350) is configured for
                    SP3_VDD_VCORE_A0 (PWR_CONT1_SP3_PG0 net)";
        } VDD_VCORE[1] = 0;
    };

    Groupc_Pg GROUPC_PG;

    // NIC readbacks
    reg {
        name = "Power Status for NIC HP supplies";
        default sw = r;
        field {
            desc = "Power good for V0P96_NIC_VDD_A0HP (PWR_CONT_NIC_PG0 net)";
        } NIC_V0P96_PG[1] = 0;
        field {
            desc = "Power good for V1P1_NIC_ETH_IO_A0HP (inverted NIC_TO_SEQ_V1P1_PG_L net)";
        } NIC_V1P1_PG[1] = 0;
        field {
            desc = "Power good for V1P2_NIC_MDIO_A0HP  (inverted NIC_TO_SEQ_V1P2_PG_L net)";
        } NIC_V1P2_PG[1] = 0;
         field {
            desc = "Power good for V1P2_NIC_ETH  (inverted NIC_TO_SEQ_V1P2_PG_L net)";
        } NIC_V1P2_ENET_PG[1] = 0;
        field {
            desc = "Power good for V1P5_NIC_AVDD_A0HP (inverted NIC_TO_SEQ_V1P5A_PG_L net)";
        } NIC_V1P5A_PG[1] = 0;
        field {
            desc = "Power good for V1P5_NIC_PCIE_MEM_A0HP (inverted NIC_TO_SEQ_V1P5D_PG_L net)";
        } NIC_V1P5D_PG[1] = 0;
        field {
            desc = "Power good for LDO_V3P3";
        } NIC_3V3_PG[1] = 0;
    } NIC_STATUS;

    reg {
        name = "Cock Generator GPIO Readbacks";
        field {
            desc = "GPIO1";
        } GPIO1[1] = 0;
        field {
            desc = "GPIO2";
        } GPIO2[1] = 0;
        field {
            desc = "GPIO3";
        } GPIO3[1] = 0;
        field {
            desc = "GPIO4";
        } GPIO4[1] = 0;
        field {
            desc = "GPIO5";
        } GPIO5[1] = 0;
        field {
            desc = "GPIO8";
        } GPIO8[1] = 0;
        field {
            desc = "GPIO9";
        } GPIO9[1] = 0;
    } CLKGEN_STATUS;

    reg {
        name = "General AMD readbacks";
        field {
            desc = "inverted CPU's thermtrip_L, 500ms to shut down power planes into S5 state. De-assertion of PWROK resets THERMTRIP_L";
        } THERMTRIP[1] = 0;
        field {
            desc = "inverted FSR_REQ_L net. Maybe used in host reset detection, see RFD138. No defined use in power-up";
        } FSR_REQ[1] = 0;
        field {
            desc = "Output from the AMD processor that it has effectively acknowledged that power is itself
                    good.  This  is  connected  from  the  BSP  to  the  AP's  PWR_GOOD  input  in  a  two  socket
                    system.  The  FCH  may  actually  control  this  being  generated  via  the
                    FCH::PM::RESETCONTROL2 register. ";
        } PWRGD_OUT[1] = 0;
        field {
            desc = "NIC_PWREN (inversion of net SP3_TO_SP_NIC_PWREN_L), available on C and newer Gimlets.
                   When Asserted high in this register, the net is active low, and NIC power is expected to
                   be commanded on by Hubris (see NIC_CTRL register).  This is a readback-only view, no 
                   autonomous FPGA action occurs on the status of this pin, Hubris also monitors and takes
                   action.  Only valid in A0 and higher power states but is a simple pass-through in the
                   FPGA, no gating logic";
        } NIC_PWREN[1] = 0;
    } AMD_STATUS;
  
    // We use this type to create both a status register for reading outputs
    // and the debug control register for forcing outputs.
    reg {
        name = "Fan Output Status";
        default sw = r;

        field {
            desc = "Enable for fan ADUM1272. (1us glitch filter at ADUM1272)";
        } FAN_HP_EN[1];
        field {
            desc = "FANHP_RESTART pin (note actual output is inverted to meet
            circuit's active low requirement, so a 1 here means a 0 on the board)";
        } FANHP_RESTART[1] = 0;
    } FANOUTSTATUS;

    reg a1_output_type {
        name = "A1 Outputs";
        default sw = r;

        field {
            desc = "Enables V3P3_SP3_VDD_33_S5_A1 rail (SEQ_TO_SP3_V3P3_S5_EN pin)";
        } V3P3_S5_EN[1] = 0;
        field {
            desc = "Enables V1P5_SP3_VDD_RTC_A1 rail (SEQ_TO_SP3_V1P5_RTC_EN pin)";
        } V1P5_RTC_EN[1] = 0;
        field {
            desc = "Enables V1P8_SP3_VDD_18_S5_A1 rail (SEQ_TO_SP3_V1P8_S5_EN pin)";
        } V1P8_S5_EN[1] = 0;
        field {
            desc = "Enables V0P9_SP3_VDD_SOC_S5_A1 rail (SEQ_TO_SP3_V0P9_S5_EN pin)";
        } V0P9_S5_EN[1] = 0;
        field {
            desc = "De-asserted to processor after GroupA supplies are stable (10ms after S5 rails minimum) 
            (SEQ_TO_SP3_RSMRST_V3P3_L net inverted from this register)";
        } RSMRST[1] = 0;
    };

    reg a0_output1_type {
        field {
            desc = "GroupB1: Drives VPP_ABCD_A0 rail (pwr_cont_dimm_en0 net RevB)";
        } VPP_ABCD_EN[1] = 0;
        field {
            desc = "GroupB1: Drives VPP_EFGH_A0 rail (pwr_cont_dimm_en1 net RevB)";
        } VPP_EFGH_EN[1] = 0;
        field {
            desc = "GroupB1: Enables V3P3_SYS_A0 rail (seq_to_v3p3_sys_en net RevB)";            
        } V3P3_SYS_EN[1] = 0;
        field {
            desc = "GroupB1: Enables V1P8_SP3_VDD_18_A0 rail (seq_to_sp3_v1p8_en net RevB)";            
        } V1P8_SP3_VDD_EN[1] = 0;
        field {
            desc = "GroupB2: Enables VDD_MEM_ABCD_A0 rail (pwr_cont1_sp3_en net RevB)";
        } VDD_MEM_ABCD_EN[1] = 0;
        field {
            desc = "GroupB2: Enables VDD_MEM_EFGH_A0 rail (pwr_cont2_sp3_en net RevB)";
        } VDD_MEM_EFGH_EN[1] = 0;
        field {
            desc = "GroupB2: Enables VTT_ABCD_A0 rail (seq_to_vtt_abcd_en net RevB)";
        } VTT_ABCD_EN[1] = 0;
        field {
            desc = "GroupB2: Enables VTT_EFGH_A0 rail (seq_to_vtt_efgh_en net RevB)";
        } VTT_EFGH_EN[1] = 0;
    };

    reg a0_output2_type {
        field {
            desc = "Strap High, no definition yet. PWROK pin to RAA229618 U350 driving 
            SP3_VDD_VCORE_A0 and VDD_MEM_ABCD_A0";
        } U350_PWROK[1] = 1;
        field {
            desc = "Strap High, no definition yet. PWROK pin to RAA229618 U351 driving
            SP3_VDDCR_SOC_A0 and VDD_MEM_EFGH_A0 (PWR_CONT2_SP3_PWROK net)";
        } U351_PWROK[1] = 1;
        field {
            desc = "Enables V1P8_SP3_VDD_18_A0 rail (SEQ_TO_SP3_V1P8_EN net)";
        } V1P8_SP3_EN[1] = 0;
        field {
            desc = "Enable for RAA229618 (U350) VDD_MEM_ABCD_A0 (PWR_CONT1_SP3_EN net)";
        } CONT1_EN[1] = 0;
        field {
            desc = "Enable for RAA229618 (U35) VDD_MEM_EFGH_A0 (and gates SP3_VDDCR_SOC_A0) 
            (PWR_CONT2_SP3_EN net)";
        } CONT2_EN[1] = 0;
        field {
            desc = "Pulsed according to AMD's EDS min 15ms (SP_TO_SP3_PWR_BTN_L net, inverted from this register)";
        } PWR_BTN[1] = 0;
        field {
            desc = "This is asserted to CPU, 1ms before asserting. Set when A0 rails are good. (SEQ_TO_SP3_PWR_GOOD net)";
        } PWR_GOOD[1] = 0; 
    };

    reg nic_output1_type {
        field {
            desc = "Enable (U565), V0P96_NIC_VDD_A0HP rail (SEQ_TO_NIC_V0P9_A0HP_EN net)";
        } NIC_V0P9_A0_EN[1] = 0;
        field {
            desc = "Turns on V1P2_NIC_ENET_A0HP, no readback (SEQ_TO_NIC_V1P2_ENET_EN net)";
        } NIC_V1P2_ETH_EN[1] = 0;
        field {
            desc = "En for V1P5_NIC_AVDD_A0HP rail (SEQ_TO_NIC_V1P5A_EN net)";
        } NIC_V1P5A_EN[1] = 0;
        field {
            desc = "En for V1P5_NIC_PCIE_MEM_A0HP rail (SEQ_TO_NIC_V1P5D_EN net)";
        } NIC_V1P5D_EN[1] = 0;
        field {
            desc = "Enable for V1P2_NIC_MDIO_A0HP rail (SEQ_TO_NIC_V1P2_EN net)";
        } NIC_V1P2_EN[1] = 0;
        field {
            desc = "Turns on V1P1_NIC_ETH_IO_A0HP rail (SEQ_TO_NIC_V1P1_EN net)";
        } NIC_V1P1_EN[1] = 0;
        field {
            desc = "Enables V3PV_NIC_A0HP rail (SEQ_TO_NIC_LDO_V3P3_EN net)";
        } NIC_V3P3_EN[1] = 0;
    };

    reg nic_output2_type {
        field {
            desc = "Input to FPGA from SP3 I/O expander (inverted)";
        } SP3_PERST[1] = 0;
        field {
            desc = "Becomes clock enable for clk_100M_TO_RSW (SEQ_TO_NIC_COMB_PG net)";
        } NIC_COMB_PG[1] = 0;
        field {
            desc = "CLD Reset to Chelsio. De-asserted after NIC power stable (SEQ_TO_NIC_CLD_RST_L net inverted)";
        } NIC_CLD_RST[1] = 0;
        field {
            desc = "Alert SP3 of a NIC power fault (NIC_TO_SP3_PWRFLT_L inverted net)";
        } PWRFLT[1] = 0;
        field {
            desc = "PERST outptut (PERST_L inverted net)";
        } NIC_PERST[1] = 0;
        field {
            desc = "NIC's EXT_RST_L output (inverted).  Active when NIC internals in reset";
        } NIC_EXT_RST[1] = 0;
    };

    reg clk_gen_output_type {
        // TODO: need to understand GPIO pinouts and functions
        field {
            desc = "CLK_TO_SEQ_NMR_L inverted to clk generator";
        } SEQ_NMR[1] = 0;
    };

    reg amd_output_type {
        field {
            desc = "CPU's `SYS_RESET_L`, see EDS. 10ms assertion time, would traditionally be wired to a PC reset button";
        } SYS_RESET[1] = 0;
    };

    // Status registers
    early_power EARLY_PWR_STATUS;
    EARLY_PWR_STATUS->name = "Early Power Output readbacks";
    a1_output_type A1_OUT_STATUS;
    A1_OUT_STATUS->name = "A1 Output readbacks"; 

    a0_output1_type A0_OUT_STATUS_1;
    A0_OUT_STATUS_1->name = "A0 Register 1 Output readbacks"; 
    a0_output2_type A0_OUT_STATUS_2;
    A0_OUT_STATUS_2->name = "A0 Register 2 Output readbacks";

    nic_output1_type OUT_STATUS_NIC1;
    OUT_STATUS_NIC1->name = "Readbacks of FPGA outputs (register 1 of 2) to NIC supplies/NIC";
    nic_output2_type OUT_STATUS_NIC2;
    OUT_STATUS_NIC2->name = "Readbacks of FPGA outputs (register 2 of 2) to NIC supplies/NIC";

    clk_gen_output_type CLKGEN_OUT_STATUS;
    CLKGEN_OUT_STATUS->name = "Readbacks of FPGA outputs to clock generator";

    amd_output_type AMD_OUT_STATUS;
    AMD_OUT_STATUS->name = "Readbacks of FPGA outputs to AMD";

    // Debug registers
    reg {
        name = "Debug Control register";
        field {
            desc = "Debug ONLY. Setting this allows the A0 state machine to ingore SP3 handshakes.
            This is potentially useful for power bringup but should not be used when a CPU is actually
            installed";
        } ignore_sp[1] = 0; 
        field {
            desc = "Un-used";
        } REG_CTRL_EN[1] = 0;
        field {
            desc = "Nic debug control only. Seeting will force CLD_RST assert until cleared. When cleared,
            CLD_RST will normally be controlled by state machine and NIC Control register";
        } NIC_CLD_RST_OVERRIDE[1] = 0;
        field {
            desc = "Nic debug control only. Setting will force Perst_L assert until cleared. When
            cleared, PERST will normally be controlled by SP3 I/O expander. Set next bit PERST_FORCE_SOLO to
            ignore all SP3 control and have this register directly control I/O regardless of SP3's PERST state";
        } NIC_PERST_OVERRIDE[1] = 0;
        field {
            desc = "Nic debug control only. Make PERST ignore any SP3 I/O and drive directly from previous bit";
        } NIC_PERST_SOLO[1] = 0;
    } DBG_CTRL;


    amd_output_type AMD_DBG_OUT;
    AMD_DBG_OUT->name = "Readbacks of FPGA outputs to AMD";

    reg amd_reset_fedge_counter {
        default sw=rw;
        default onwrite=wclr;
        field {
            desc = "Falling edge counter of AMD's reset output while in A0/A0HP. Saturates at 255. Any write clears";
        } RESET_CNTS[7:0] = 0;
    } AMD_RSTN_CNTS;

    reg amd_pwrok_fedge_counter {
        default sw=rw;
        default onwrite=wclr;
        field {
            desc = "Falling edge counter of AMD's PowerOK output while in A0/A0HP. Saturates at 255.  Any write clears";
        } RESET_CNTS[7:0] = 0;
    }AMD_PWROKN_CNTS;

    // MAX hold debug regs
    a0_sm DBG_MAX_A0SMSTATUS;
    DBG_MAX_A0SMSTATUS->name = "A0 SM status (Max-hold)";
    Groupb_Pg MAX_GROUPB_PG;
    MAX_GROUPB_PG->name = "Group B PGs (Max-hold)";
    Groupc_Pg MAX_GROUPC_PG;
    MAX_GROUPC_PG->name = "Group C PGs (Max-hold)";

    // Fault debug regs
    a0_sm FLT_A0_SMSTATUS;
    FLT_A0_SMSTATUS->name = "A0 SM status (latched at fault)";
    Groupb_Pg FLT_GROUPB_PG;
    FLT_GROUPB_PG->name = "Group B PGs latched at fault";
    Groupc_Pg FLT_GROUPC_PG;
    FLT_GROUPC_PG->name = "Group C PGs latched at fault";

    reg {
        name = "Miscellaneous control register";

        field {
            desc = "Control of the seq_proxy_sp3_to_rsw_pwren_l pin (inverted by FPGA, so a '1' here will drive the pin low)";
        } RSW_PWREN[0:0] = 0;
    } MISC_CTRL;
};