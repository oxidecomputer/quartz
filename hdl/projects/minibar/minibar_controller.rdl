// Copyright 2025 Oxide Computer Company
//
// This Source Code Form is subject to the terms of the Mozilla Public
// License, v. 2.0. If a copy of the MPL was not distributed with this
// file, You can obtain one at https://mozilla.org/MPL/2.0/.

addrmap minibar_controller {
    name = "Minibar Controller";
    desc = "Register description of the Minibar Controller";

    default regwidth = 8;
    default sw = rw;
    default hw = r;

    //
    // Identification Registers
    // Read-only bits showing 0x1de
    //
    reg {
        name = "Identification 0";
        default sw = r;
        field {
            desc = "Byte 0 of ID";
        } ID0[7:0] = 0x01;
    } ID0;

    reg {
        name = "Identification 1";
        default sw = r;
        field {
            desc = "Byte 1 of ID";
        } ID1[7:0] = 0xde;
    } ID1;

    reg {
        name = "Identification 2";
        default sw = r;
        field {
            desc = "Byte 2 of ID";
        } ID2[7:0] = 0x5b;
    } ID2;

    reg {
        name = "Identification 3";
        default sw = r;
        field {
            desc = "Byte 3 of ID";
        } ID3[7:0] = 0xae;
    } ID3;

    //
    // Checksum utilized by the SP
    //
    reg {
        name = "Checksum 0";
        field {
            desc = "checksum[31..24]";
        } CS0[7:0] = 0;
    } CS0;

    reg {
        name = "Checksum 1";
        field {
            desc = "checksum[23..16]";
        } CS1[7:0] = 0;
    } CS1;

    reg {
        name = "Checksum 2";
        field {
            desc = "checksum[15..8]";
        } CS2[7:0] = 0;
    } CS2;

    reg {
        name = "Checksum 3";
        field {
            desc = "checksum[7..0]";
        } CS3[7:0] = 0;
    } CS3;

    reg {
        name = "Version 0";
        default sw = r;
        field {
            desc = "version[31..24]";
        } data[7:0] = 0;
    } VERSION0;

    reg {
        name = "Version 1";
        default sw = r;
        field {
            desc = "version[23..16]";
        } data[7:0] = 0;
    } VERSION1;

    reg {
        name = "Version 2";
        default sw = r;
        field {
            desc = "version[15..8]";
        } data[7:0] = 0;
    } VERSION2;

    reg {
        name = "Version 3";
        default sw = r;
        field {
            desc = "version[7..0]";
        } data[7:0] = 0;
    } VERSION3;

    reg {
        name = "Short SHA 0";
        default sw = r;
        field {
            desc = "sha[31..24]";
        } data[7:0] = 0;
    } SHA0;

    reg {
        name = "Short SHA 1";
        default sw = r;
        field {
            desc = "sha[23..16]";
        } data[7:0] = 0;
    } SHA1;

    reg {
        name = "Short SHA 2";
        default sw = r;
        field {
            desc = "sha[15..8]";
        } data[7:0] = 0;
    } SHA2;

    reg {
        name = "Short SHA 3";
        default sw = r;
        field {
            desc = "sha[7..0]";
        } data[7:0] = 0;
    } SHA3;

    reg {
        name = "Scratchpad";
        field {
            desc = "Scribble Register for read-write use";
        } SCRATCHPAD[7:0] = 0;
    } SCRATCHPAD;

    // Miscellaneous Top-level Registers

    // Hardware Compatibility Version
    // See RFD 438
    reg {
        name = "Hardware Compatibility Version Code";
        default sw = r;
        field {
            desc = "HCV Code";
        } code[2:0] = 0;
    } HCV;

    reg {
        name = "Readbacks attempting to establish presence for an attached sled's EXAMAX connectors.";

        field {
            desc = "Inverted value of pcie_examax_to_fpga_sled_present_l pin";
        } pcie_present[2:2] = 0;

        field {
            desc = "Inverted value of rsw1_examax_to_fpga_sled_present_l pin";
        } rsw1_present[1:1] = 0;

        field {
            desc = "Inverted value of rsw0_examax_to_fpga_sled_present_l pin";
        } rsw0_present[0:0] = 0;
    } SLED_PRESENCE;

    reg {
        name = "VBUS_SYS Readbacks";
        default sw = r;
        field {
            desc = "Inverted value of the vbus_sys_hsc_to_fpga_fault_l pin";
        } fault[0:0] = 0;
    } VBUS_SYS_RDBK;

    reg {
        name = "Software power rail control";

        field {
            desc = "fpga_to_vbus_sys_hsc_restart_l pin control (active high, FPGA will invert)";
        } vbus_sys_restart[5:5] = 0;

        field {
            desc = "fpga_to_vbus_sled_hsc_restart_l pin control (active high, FPGA will invert)";
        } vbus_sled_restart[4:4] = 0;

        field {
            desc = "fpga_to_vbus_sled_hsc_en pin control";
        } vbus_sled_en[0:0] = 0;
    } POWER_CTRL;

    reg power_rail_state {
        regwidth = 8;
        default sw = r;

        enum state {
            Disabled = 3'h0 {desc = "Rail is disabled";};
            RampingUp = 3'h1 {desc = "Rail is ramping up";};
            TimedOut = 3'h2 {desc = "Timed out before PG was observed";};
            Aborted = 3'h3 {desc = "PG disappeared after previously being asserted";};
            Enabled = 3'h4 {desc = "Rail was enabled and PG was observed";};
        };
        field {
            desc = "State of the FPGA-internal power rail sequencer";
            encode = state;
        } state[7:5] = 0;

        field {
            desc = "Status of the enable pin";
        } enable_pin[2:2] = 0;

        field {
            desc = "Status of the power good pin";
        } pg_pin[1:1] = 0;

        field {
            desc = "Status of the fault pin (normalized to '1'=fault)";
        } fault_pin[0:0] = 0;
    };

    power_rail_state vbus_sled;

    reg {
        name = "Control for the VSC7448 and VSC8504 reset lines.";

        field {
            desc = "fpga_to_vsc7448_reset_l pin control (active high, FPGA will invert)";
        } vsc7448_reset[1:1] = 0;

        field {
            desc = "fpga_to_vsc8504_reset_l_3p3 pin control (active high, FPGA will invert)";
        } vsc8504_reset[0:0] = 0;
    } SWITCH_RESET_CTRL;

    //
    // PCIe Stuff
    //

    reg {
        name = "Software PCIe power rail control";

        field {
            desc = "fpga_to_v12_pcie_efuse_en pin control";
        } v12_pcie_en[1:1] = 1;
        field {
            desc = "fpga_to_v3p3_pcie_efuse_en pin control";
        } v3p3_pcie_en[0:0] = 1;
    } PCIE_POWER_CTRL;

    power_rail_state v12_pcie;
    power_rail_state v3p3_pcie;

    reg {
        name = "Control for the PI6CB33201 PCIe Reference Clock Buffer";

        enum bw_sel {
            PllLowBw = 2'h0 {desc = "PLL with Low Bandwidth";};
            PllHighBw = 2'h1 {desc = "PLL with High Bandwidth";};
            PllBypass = 2'h2 {desc = "PLL Bypass";};
        };
        field {
            desc = "fpga_to_pcie_aux_refclk_buffer_bw_sel pin control";
            encode = bw_sel;
        } bw_sel[4:3] = 0;

        field {
            desc = "fpga_to_pcie_aux_refclk_buffer_pd_l pin control (active high, FPGA will invert)";
        } pd[2:2] = 0;

        field {
            desc = "fpga_to_pcie_aux_refclk_buffer_oe1_l pin control (active high, FPGA will invert)";
        } oe1[1:1] = 0;

        field {
            desc = "fpga_to_pcie_aux_refclk_buffer_oe0_l pin control (active high, FPGA will invert)";
        } oe0[0:0] = 0;
    } PCIE_REFCLK_CTRL;

    reg {
        name = "Control for the PCIe interface related signals";

        field {
            desc = "control of pcie_aux_fpga_to_sled_pwrflt_l (active high, FPGA will invert)";
        } sled_pwrflt[3:3] = 0;

        field {
            desc = "control of fpga_to_sled_pcie_attached_l (active high, FPGA will invert)";
        } attached[2:2] = 0;

        field {
            desc = "control of fpga_to_pcie_cem_i2c_buffer_en";
        } cem_i2c_en[1:1] = 1;

        field {
            desc = "control of fpga_to_pcie_sled_i2c_buffer_en";
        } sled_i2c_en[0:0] = 1;
    } PCIE_CTRL;

    reg {
        name = "Readbacks for the PCIe signals.";
        default sw = r;

        field {
            desc = "pcie_aux_fpga_to_cem_prsnt_l pin readback (normalized to active high)";
        } cem_prsnt[5:5] = 0;

        field {
            desc = "pcie_aux_sled_to_fpga_perst_l pin readback (normalized to active high)";
        } cem_perst[4:4] = 0;

        field {
            desc = "pcie_aux_fpga_to_cem_prsnt_l pin readback (normalized to active high)";
        } sled_prsnt[1:1] = 0;

        field {
            desc = "pcie_aux_sled_to_fpga_perst_l pin readback (normalized to active high)";
        } sled_perst[0:0] = 0;
    } PCIE_RDBK;

    //
    // Ignition Stuff
    //
    reg {
        name = "Ignition Targets Present";
        default sw = r;

        field {
            desc = "Target 1 present";
        } target1_present[1:1] = 0;

        field {
            desc = "Target 0 present";
        } target0_present[0:0] = 0;
    } IGNITION_TARGETS_PRESENT;

    ignition_controller IGNITION_CONTROLLER0 @ 0x100;
    ignition_controller IGNITION_CONTROLLER1 @ 0x200;
};