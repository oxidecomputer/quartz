// Copyright 2025 Oxide Computer Company
//
// This Source Code Form is subject to the terms of the Mozilla Public
// License, v. 2.0. If a copy of the MPL was not distributed with this
// file, You can obtain one at https://mozilla.org/MPL/2.0/.

addrmap minibar_controller {
    name = "Minibar Controller";
    desc = "Register description of the Minibar Controller";

    default regwidth = 8;
    default sw = rw;
    default hw = r;

    //
    // Identification Registers
    // Read-only bits showing 0x1de
    //
    reg {
        name = "Identification 0";
        default sw = r;
        field {
            desc = "Byte 0 of ID";
        } ID0[7:0] = 0x01;
    } ID0;

    reg {
        name = "Identification 1";
        default sw = r;
        field {
            desc = "Byte 1 of ID";
        } ID1[7:0] = 0xde;
    } ID1;

    reg {
        name = "Identification 2";
        default sw = r;
        field {
            desc = "Byte 2 of ID";
        } ID2[7:0] = 0x5b;
    } ID2;

    reg {
        name = "Identification 3";
        default sw = r;
        field {
            desc = "Byte 3 of ID";
        } ID3[7:0] = 0xae;
    } ID3;

    //
    // Checksum utilized by the SP
    //
    reg {
        name = "Checksum 0";
        field {
            desc = "checksum[31..24]";
        } CS0[7:0] = 0;
    } CS0;

    reg {
        name = "Checksum 1";
        field {
            desc = "checksum[23..16]";
        } CS1[7:0] = 0;
    } CS1;

    reg {
        name = "Checksum 2";
        field {
            desc = "checksum[15..8]";
        } CS2[7:0] = 0;
    } CS2;

    reg {
        name = "Checksum 3";
        field {
            desc = "checksum[7..0]";
        } CS3[7:0] = 0;
    } CS3;

    reg {
        name = "Version 0";
        default sw = r;
        field {
            desc = "version[31..24]";
        } DATA[7:0] = 0;
    } VERSION0;

    reg {
        name = "Version 1";
        default sw = r;
        field {
            desc = "version[23..16]";
        } DATA[7:0] = 0;
    } VERSION1;

    reg {
        name = "Version 2";
        default sw = r;
        field {
            desc = "version[15..8]";
        } DATA[7:0] = 0;
    } VERSION2;

    reg {
        name = "Version 3";
        default sw = r;
        field {
            desc = "version[7..0]";
        } DATA[7:0] = 0;
    } VERSION3;

    reg {
        name = "Short SHA 0";
        default sw = r;
        field {
            desc = "sha[31..24]";
        } DATA[7:0] = 0;
    } SHA0;

    reg {
        name = "Short SHA 1";
        default sw = r;
        field {
            desc = "sha[23..16]";
        } DATA[7:0] = 0;
    } SHA1;

    reg {
        name = "Short SHA 2";
        default sw = r;
        field {
            desc = "sha[15..8]";
        } DATA[7:0] = 0;
    } SHA2;

    reg {
        name = "Short SHA 3";
        default sw = r;
        field {
            desc = "sha[7..0]";
        } DATA[7:0] = 0;
    } SHA3;

    reg {
        name = "Scratchpad";
        field {
            desc = "Scribble Register for read-write use";
        } SCRATCHPAD[7:0] = 0;
    } SCRATCHPAD;

    // Miscellaneous Top-level Registers

    // Hardware Compatibility Version
    // See RFD 438
    reg {
        name = "Hardware Compatibility Version Code";
        default sw = r;
        field {
            desc = "HCV Code";
        } CODE[2:0] = 0;
    } HCV;

    reg {
        name = "Readbacks attempting to establish presence for an attached sled's EXAMAX connectors.";

        field {
            desc = "Inverted value of pcie_examax_to_fpga_sled_present_l pin";
        } PCIE_PRESENT[2:2] = 0;

        field {
            desc = "Inverted value of rsw1_examax_to_fpga_sled_present_l pin";
        } RSW1_PRESENT[1:1] = 0;

        field {
            desc = "Inverted value of rsw0_examax_to_fpga_sled_present_l pin";
        } RSW0_PRESENT[0:0] = 0;
    } SLED_PRESENCE;

    reg {
        name = "VBUS_SYS Readbacks";
        default sw = r;
        field {
            desc = "Inverted value of the vbus_sys_hsc_to_fpga_fault_l pin";
        } FAULT[0:0] = 0;
    } VBUS_SYS_RDBK;

    reg {
        name = "Software power rail control";

        field {
            desc = "fpga_to_vbus_sys_hsc_restart_l pin control (active high, FPGA will invert)";
        } VBUS_SYS_RESTART[5:5] = 0;

        field {
            desc = "fpga_to_vbus_sled_hsc_restart_l pin control (active high, FPGA will invert)";
        } VBUS_SLED_RESTART[4:4] = 0;

        field {
            desc = "fpga_to_vbus_sled_hsc_en pin control";
        } VBUS_SLED_EN[0:0] = 0;
    } POWER_CTRL;

    reg power_rail_state {
        regwidth = 8;
        default sw = r;

        enum state {
            Disabled = 3'h0 {desc = "Rail is disabled";};
            RampingUp = 3'h1 {desc = "Rail is ramping up";};
            TimedOut = 3'h2 {desc = "Timed out before PG was observed";};
            Aborted = 3'h3 {desc = "PG disappeared after previously being asserted";};
            Enabled = 3'h4 {desc = "Rail was enabled and PG was observed";};
        };
        field {
            desc = "State of the FPGA-internal power rail sequencer";
            encode = state;
        } STATE[6:4] = 0;

        field {
            desc = "Status of the enable pin";
        } ENABLE_PIN[2:2] = 0;

        field {
            desc = "Status of the power good pin";
        } PG_PIN[1:1] = 0;

        field {
            desc = "Status of the fault pin (normalized to '1'=fault)";
        } FAULT_PIN[0:0] = 0;
    };

    power_rail_state vbus_sled;

    reg {
        name = "Control for the VSC7448 and VSC8504 reset lines.";

        field {
            desc = "fpga_to_vsc7448_reset_l pin control (active high, FPGA will invert)";
        } VSC7448_RESET[1:1] = 0;

        field {
            desc = "fpga_to_vsc8504_reset_l_3p3 pin control (active high, FPGA will invert)";
        } VSC8504_RESET[0:0] = 0;
    } SWITCH_RESET_CTRL;

    //
    // PCIe Stuff
    //

    reg {
        name = "Software PCIe power rail control";

        field {
            desc = "fpga_to_v12_pcie_efuse_en pin control";
        } V12_PCIE_EN[1:1] = 1;
        field {
            desc = "fpga_to_v3p3_pcie_efuse_en pin control";
        } V3P3_PCIE_EN[0:0] = 1;
    } PCIE_POWER_CTRL;

    power_rail_state v12_pcie;
    power_rail_state v3p3_pcie;

    reg {
        name = "Control for the PI6CB33201 PCIe Reference Clock Buffer";

        enum bw_sel {
            PllLowBw = 2'h0 {desc = "PLL with Low Bandwidth";};
            PllHighBw = 2'h1 {desc = "PLL with High Bandwidth";};
            PllBypass = 2'h2 {desc = "PLL Bypass";};
        };
        field {
            desc = "fpga_to_pcie_aux_refclk_buffer_bw_sel pin control. Default to High Bandwidth since sleds will have SSC enabled.";
            encode = bw_sel;
        } BW_SEL[4:3] = 1;

        field {
            desc = "fpga_to_pcie_aux_refclk_buffer_pd_l pin control (active high, FPGA will invert)";
        } PD[2:2] = 1;

        field {
            desc = "fpga_to_pcie_aux_refclk_buffer_oe1_l pin control (active high, FPGA will invert). Goes to slot.";
        } OE1[1:1] = 1;

        field {
            desc = "fpga_to_pcie_aux_refclk_buffer_oe0_l pin control (active high, FPGA will invert). Goes to test points.";
        } OE0[0:0] = 0;
    } PCIE_REFCLK_CTRL;

    reg {
        name = "Control for the PCIe interface related signals";

        field {
            desc = "control of pcie_aux_fpga_to_sled_pwrflt_l (active high, FPGA will invert)";
        } SLED_PWRFLT[3:3] = 0;

        field {
            desc = "control of fpga_to_sled_pcie_attached_l (active high, FPGA will invert)";
        } ATTACHED[2:2] = 0;

        field {
            desc = "control of fpga_to_pcie_cem_i2c_buffer_en";
        } CEM_I2C_EN[1:1] = 1;

        field {
            desc = "control of fpga_to_pcie_sled_i2c_buffer_en";
        } SLED_I2C_EN[0:0] = 1;
    } PCIE_CTRL;

    reg {
        name = "Readbacks for the PCIe signals.";
        default sw = r;

        field {
            desc = "pcie_aux_cem_to_fpga_prsnt_l pin readback (normalized to active high)";
        } CEM_PRSNT[5:5] = 0;

        field {
            desc = "pcie_aux_fpga_to_cem_perst_l pin readback (normalized to active high)";
        } CEM_PERST[4:4] = 0;

        field {
            desc = "pcie_aux_fpga_to_sled_prsnt_l pin readback (normalized to active high)";
        } SLED_PRSNT[1:1] = 0;

        field {
            desc = "pcie_aux_sled_to_fpga_perst_l pin readback (normalized to active high)";
        } SLED_PERST[0:0] = 0;
    } PCIE_RDBK;

    //
    // Ignition Stuff
    //
    reg {
        name = "Ignition Targets Present";
        default sw = r;

        field {
            desc = "Target 1 present";
        } TARGET1_PRESENT[1:1] = 0;

        field {
            desc = "Target 0 present";
        } TARGET0_PRESENT[0:0] = 0;
    } IGNITION_TARGETS_PRESENT;

    ignition_controller IGNITION_CONTROLLER0 @ 0x100;
    ignition_controller IGNITION_CONTROLLER1 @ 0x200;
};