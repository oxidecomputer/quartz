// Copyright 2022 Oxide Computer Company
//
// This Source Code Form is subject to the terms of the Mozilla Public
// License, v. 2.0. If a copy of the MPL was not distributed with this
// file, You can obtain one at https://mozilla.org/MPL/2.0/.

//
// QSFP Modules Top Address Map
//

addrmap qsfp_modules_top {
    name = "QSFP Module Top Registers";
    desc = "Collection of status and control registers for all QSFP modules";

    default regwidth = 8;
    default sw = rw;
    default hw = rw;

    //
    // I2C
    //

    reg {
        name = "QSFP module I2C address";

        field {
            desc = "I2C Address of QSFP module (reset: 7'b1010000)";
        } ADDR[6:0] = 7'b1010000;
    } I2C_BUS_ADDR;

    reg {
        name = "QSFP module register address";

        field {
            desc = "QSFP module register address";
        } ADDR[7:0] = 0;
    } I2C_REG_ADDR;

    reg {
        field {
            desc = "Number of bytes to read/write in the I2C transaction. up to 128 bytes.";
        } COUNT[7:0] = 1;
    } I2C_NUM_BYTES;

    reg {
        name = "Ports 0 -> 7 Broadcast Control";
        field {} PORT7[7:7] = 0;
        field {} PORT6[6:6] = 0;
        field {} PORT5[5:5] = 0;
        field {} PORT4[4:4] = 0;
        field {} PORT3[3:3] = 0;
        field {} PORT2[2:2] = 0;
        field {} PORT1[1:1] = 0;
        field {} PORT0[0:0] = 0;
    } I2C_BCAST0;

    reg {
        name = "Ports 8 -> 15 Broadcast Control";
        field {} PORT15[7:7] = 0;
        field {} PORT14[6:6] = 0;
        field {} PORT13[5:5] = 0;
        field {} PORT12[4:4] = 0;
        field {} PORT11[3:3] = 0;
        field {} PORT10[2:2] = 0;
        field {} PORT9[1:1] = 0;
        field {} PORT8[0:0] = 0;
    } I2C_BCAST1;

    reg {
        name = "Control bits for I2C communication.";

        field {
            desc = "2'b00 to read, 2'b01 to write, 2'b10 to random-read.";
        } OP[2:1] = 0;

        field {
            desc = "'1' to start next transaction.";
        } START[0:0] = 0;
    } I2C_CTRL;

    reg {
        default sw = r;
        name = "Ports 0 -> 7 I2C core status. '1' is busy.";
        field {} PORT7[7:7] = 0;
        field {} PORT6[6:6] = 0;
        field {} PORT5[5:5] = 0;
        field {} PORT4[4:4] = 0;
        field {} PORT3[3:3] = 0;
        field {} PORT2[2:2] = 0;
        field {} PORT1[1:1] = 0;
        field {} PORT0[0:0] = 0;
    } I2C_BUSY0;

    reg {
        default sw = r;
        name = "Ports 8 -> 15 I2C core status. '1' is busy.";
        field {} PORT15[7:7] = 0;
        field {} PORT14[6:6] = 0;
        field {} PORT13[5:5] = 0;
        field {} PORT12[4:4] = 0;
        field {} PORT11[3:3] = 0;
        field {} PORT10[2:2] = 0;
        field {} PORT9[1:1] = 0;
        field {} PORT8[0:0] = 0;
    } I2C_BUSY1;

    reg port_status {
        default sw = r;
        field {
            desc = "'1' if the bus is busy.";
        } BUSY[4:4] = 0;

        enum error_types {
            NoError = 4'h0 {desc = "All good!";};
            NoModule = 4'h1 {desc = "No module found (ModPrsL = 1)";};
            NoPower = 4'h2 {desc = "Power not enabled";};
            PowerFault = 4'h3 {desc = "Power good timed out or lost";};
            NotInitialized = 4'h4 {desc = "Module has not been out of reset for duration of t_init";};
            I2cAddressNack = 4'h5 {desc = "Module nack'd the address";};
            I2cByteNack = 4'h6 {desc = "Module nack'd a byte";};
        };

        field {
            desc = "Port I2C error status";
            encode = error_types;
        } ERROR[3:0] = 0;
    };

    port_status STATUS_PORT0;
    port_status STATUS_PORT1;
    port_status STATUS_PORT2;
    port_status STATUS_PORT3;
    port_status STATUS_PORT4;
    port_status STATUS_PORT5;
    port_status STATUS_PORT6;
    port_status STATUS_PORT7;
    port_status STATUS_PORT8;
    port_status STATUS_PORT9;
    port_status STATUS_PORT10;
    port_status STATUS_PORT11;
    port_status STATUS_PORT12;
    port_status STATUS_PORT13;
    port_status STATUS_PORT14;
    port_status STATUS_PORT15;

    reg port_control {
        field {
            desc ="Setting this bit will clear a fault state. Note that if the power supply is not Aborted or TimedOut, nothing will happen. This bit auto-clears.";
        } CLEAR_FAULT[0:0] = 0;
    };

    port_control CONTROL_PORT0;
    port_control CONTROL_PORT1;
    port_control CONTROL_PORT2;
    port_control CONTROL_PORT3;
    port_control CONTROL_PORT4;
    port_control CONTROL_PORT5;
    port_control CONTROL_PORT6;
    port_control CONTROL_PORT7;
    port_control CONTROL_PORT8;
    port_control CONTROL_PORT9;
    port_control CONTROL_PORT10;
    port_control CONTROL_PORT11;
    port_control CONTROL_PORT12;
    port_control CONTROL_PORT13;
    port_control CONTROL_PORT14;
    port_control CONTROL_PORT15;

    reg {
        name = "Ports 0 -> 7 HSC Enable. Clear bit to remove module power.";
        default sw = r;
        field {} PORT7[7:7] = 1;
        field {} PORT6[6:6] = 1;
        field {} PORT5[5:5] = 1;
        field {} PORT4[4:4] = 1;
        field {} PORT3[3:3] = 1;
        field {} PORT2[2:2] = 1;
        field {} PORT1[1:1] = 1;
        field {} PORT0[0:0] = 1;
    } POWER_EN0;

    reg {
        name = "Ports 8 -> 15 HSC Enable. Clear bit to remove module power.";
        default sw = r;
        field {} PORT15[7:7] = 1;
        field {} PORT14[6:6] = 1;
        field {} PORT13[5:5] = 1;
        field {} PORT12[4:4] = 1;
        field {} PORT11[3:3] = 1;
        field {} PORT10[2:2] = 1;
        field {} PORT9[1:1] = 1;
        field {} PORT8[0:0] = 1;
    } POWER_EN1;

    reg {
        name = "Ports 0 -> 7 HSC power good";
        default sw = r;
        field {} PORT7[7:7] = 0;
        field {} PORT6[6:6] = 0;
        field {} PORT5[5:5] = 0;
        field {} PORT4[4:4] = 0;
        field {} PORT3[3:3] = 0;
        field {} PORT2[2:2] = 0;
        field {} PORT1[1:1] = 0;
        field {} PORT0[0:0] = 0;
    } POWER_GOOD0;

    reg {
        name = "Ports 8 -> 15 HSC power good";
        default sw = r;
        field {} PORT15[7:7] = 0;
        field {} PORT14[6:6] = 0;
        field {} PORT13[5:5] = 0;
        field {} PORT12[4:4] = 0;
        field {} PORT11[3:3] = 0;
        field {} PORT10[2:2] = 0;
        field {} PORT9[1:1] = 0;
        field {} PORT8[0:0] = 0;
    } POWER_GOOD1;

    reg {
        name = "Ports 0 -> 7 HSC power good not asserted within period after enabled";
        default sw = r;
        field {} PORT7[7:7] = 0;
        field {} PORT6[6:6] = 0;
        field {} PORT5[5:5] = 0;
        field {} PORT4[4:4] = 0;
        field {} PORT3[3:3] = 0;
        field {} PORT2[2:2] = 0;
        field {} PORT1[1:1] = 0;
        field {} PORT0[0:0] = 0;
    } POWER_GOOD_TIMEOUT0;

    reg {
        name = "Ports 8 -> 15 HSC power good not asserted within period after enabled";
        default sw = r;
        field {} PORT15[7:7] = 0;
        field {} PORT14[6:6] = 0;
        field {} PORT13[5:5] = 0;
        field {} PORT12[4:4] = 0;
        field {} PORT11[3:3] = 0;
        field {} PORT10[2:2] = 0;
        field {} PORT9[1:1] = 0;
        field {} PORT8[0:0] = 0;
    } POWER_GOOD_TIMEOUT1;

    reg {
        name = "Ports 0 -> 7 HSC power good lost after successful enable";
        default sw = r;
        field {} PORT7[7:7] = 0;
        field {} PORT6[6:6] = 0;
        field {} PORT5[5:5] = 0;
        field {} PORT4[4:4] = 0;
        field {} PORT3[3:3] = 0;
        field {} PORT2[2:2] = 0;
        field {} PORT1[1:1] = 0;
        field {} PORT0[0:0] = 0;
    } POWER_GOOD_LOST0;

    reg {
        name = "Ports 8 -> 15 HSC power good lost after successful enable";
        default sw = r;
        field {} PORT15[7:7] = 0;
        field {} PORT14[6:6] = 0;
        field {} PORT13[5:5] = 0;
        field {} PORT12[4:4] = 0;
        field {} PORT11[3:3] = 0;
        field {} PORT10[2:2] = 0;
        field {} PORT9[1:1] = 0;
        field {} PORT8[0:0] = 0;
    } POWER_GOOD_LOST1;

    reg {
        name = "Ports 0 -> 7 Module ResetL";
        field {} PORT7[7:7] = 0;
        field {} PORT6[6:6] = 0;
        field {} PORT5[5:5] = 0;
        field {} PORT4[4:4] = 0;
        field {} PORT3[3:3] = 0;
        field {} PORT2[2:2] = 0;
        field {} PORT1[1:1] = 0;
        field {} PORT0[0:0] = 0;
    } MOD_RESETL0;

    reg {
        name = "Ports 8 -> 15 Module ResetL";
        field {} PORT15[7:7] = 0;
        field {} PORT14[6:6] = 0;
        field {} PORT13[5:5] = 0;
        field {} PORT12[4:4] = 0;
        field {} PORT11[3:3] = 0;
        field {} PORT10[2:2] = 0;
        field {} PORT9[1:1] = 0;
        field {} PORT8[0:0] = 0;
    } MOD_RESETL1;

    reg {
        name = "Ports 0 -> 7 Module LPMode/TxDis";
        field {} PORT7[7:7] = 0;
        field {} PORT6[6:6] = 0;
        field {} PORT5[5:5] = 0;
        field {} PORT4[4:4] = 0;
        field {} PORT3[3:3] = 0;
        field {} PORT2[2:2] = 0;
        field {} PORT1[1:1] = 0;
        field {} PORT0[0:0] = 0;
    } MOD_LPMODE0;

    reg {
        name = "Ports 8 -> 15 Module LPMode/TxDis";
        field {} PORT15[7:7] = 0;
        field {} PORT14[6:6] = 0;
        field {} PORT13[5:5] = 0;
        field {} PORT12[4:4] = 0;
        field {} PORT11[3:3] = 0;
        field {} PORT10[2:2] = 0;
        field {} PORT9[1:1] = 0;
        field {} PORT8[0:0] = 0;
    } MOD_LPMODE1;

    reg {
        name = "Ports 0 -> 7 Module ModPrsL";
        default sw = r;
        field {} PORT7[7:7] = 0;
        field {} PORT6[6:6] = 0;
        field {} PORT5[5:5] = 0;
        field {} PORT4[4:4] = 0;
        field {} PORT3[3:3] = 0;
        field {} PORT2[2:2] = 0;
        field {} PORT1[1:1] = 0;
        field {} PORT0[0:0] = 0;
    } MOD_MODPRSL0;

    reg {
        name = "Ports 8 -> 15 Module ModPrsL";
        default sw = r;
        field {} PORT15[7:7] = 0;
        field {} PORT14[6:6] = 0;
        field {} PORT13[5:5] = 0;
        field {} PORT12[4:4] = 0;
        field {} PORT11[3:3] = 0;
        field {} PORT10[2:2] = 0;
        field {} PORT9[1:1] = 0;
        field {} PORT8[0:0] = 0;
    } MOD_MODPRSL1;

    reg {
        name = "Ports 0 -> 7 Module IntL/RxLOS";
        default sw = r;
        field {} PORT7[7:7] = 0;
        field {} PORT6[6:6] = 0;
        field {} PORT5[5:5] = 0;
        field {} PORT4[4:4] = 0;
        field {} PORT3[3:3] = 0;
        field {} PORT2[2:2] = 0;
        field {} PORT1[1:1] = 0;
        field {} PORT0[0:0] = 0;
    } MOD_INTL0;

    reg {
        name = "Ports 8 -> 15 Module IntL/RxLOS";
        default sw = r;
        field {} PORT15[7:7] = 0;
        field {} PORT14[6:6] = 0;
        field {} PORT13[5:5] = 0;
        field {} PORT12[4:4] = 0;
        field {} PORT11[3:3] = 0;
        field {} PORT10[2:2] = 0;
        field {} PORT9[1:1] = 0;
        field {} PORT8[0:0] = 0;
    } MOD_INTL1;

    //
    // I2C Write and Read Buffers
    // Status register colocated with the read buffer so we can grab the status
    // and all the bits in the same transaction.
    //

    mem read_buffer {
        mementries = 128;
        memwidth = 8;
    };

    mem write_buffer {
        mementries = 128;
        memwidth = 8;
    };

    port_status PORT0_STATUS @0x007F;
    external read_buffer PORT0_READ_BUFFER @0x0080;

    port_status PORT1_STATUS @0x017F;
    external read_buffer PORT1_READ_BUFFER @0x0180;

    port_status PORT2_STATUS @0x027F;
    external read_buffer PORT2_READ_BUFFER @0x0280;

    port_status PORT3_STATUS @0x037F;
    external read_buffer PORT3_READ_BUFFER @0x0380;

    port_status PORT4_STATUS @0x047F;
    external read_buffer PORT4_READ_BUFFER @0x0480;

    port_status PORT5_STATUS @0x057F;
    external read_buffer PORT5_READ_BUFFER @0x0580;

    port_status PORT6_STATUS @0x067F;
    external read_buffer PORT6_READ_BUFFER @0x0680;

    port_status PORT7_STATUS @0x077F;
    external read_buffer PORT7_READ_BUFFER @0x0780;

    port_status PORT8_STATUS @0x087F;
    external read_buffer PORT8_READ_BUFFER @0x0880;

    port_status PORT9_STATUS @0x097F;
    external read_buffer PORT9_READ_BUFFER @0x0980;

    port_status PORT10_STATUS @0x0A7F;
    external read_buffer PORT10_READ_BUFFER @0x0A80;

    port_status PORT11_STATUS @0x0B7F;
    external read_buffer PORT11_READ_BUFFER @0x0B80;

    port_status PORT12_STATUS @0x0C7F;
    external read_buffer PORT12_READ_BUFFER @0x0C80;

    port_status PORT13_STATUS @0x0D7F;
    external read_buffer PORT13_READ_BUFFER @0x0D80;

    port_status PORT14_STATUS @0x0E7F;
    external read_buffer PORT14_READ_BUFFER @0x0E80;

    port_status PORT15_STATUS @0x0F7F;
    external read_buffer PORT15_READ_BUFFER @0x0F80;

    external write_buffer WRITE_BUFFER;
};
