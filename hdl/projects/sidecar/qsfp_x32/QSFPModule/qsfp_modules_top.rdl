// Copyright 2022 Oxide Computer Company
//
// This Source Code Form is subject to the terms of the Mozilla Public
// License, v. 2.0. If a copy of the MPL was not distributed with this
// file, You can obtain one at https://mozilla.org/MPL/2.0/.

//
// QSFP Modules Top Address Map
//

addrmap qsfp_modules_top {
    name = "QSFP Module Top Registers";
    desc = "Collection of status and control registers for all QSFP modules";

    default regwidth = 8;
    default sw = rw;
    default hw = rw;

    //
    // I2C
    //

    reg {
        name = "QSFP module I2C address";

        field {
            desc = "I2C Address of QSFP module (reset: 7'b1010000)";
        } ADDR[6:0] = 7'b1010000;
    } I2C_BUS_ADDR;

    reg {
        name = "QSFP module register address";

        field {
            desc = "QSFP module register address";
        } ADDR[7:0] = 0;
    } I2C_REG_ADDR;

    reg {
        field {
            desc = "Number of bytes to read/write in the I2C transaction. up to 128 bytes.";
        } COUNT[7:0] = 1;
    } I2C_NUM_BYTES;

    reg {
        name = "Ports 0 -> 7 Broadcast Control";
        field {} PORT7[7:7] = 0;
        field {} PORT6[6:6] = 0;
        field {} PORT5[5:5] = 0;
        field {} PORT4[4:4] = 0;
        field {} PORT3[3:3] = 0;
        field {} PORT2[2:2] = 0;
        field {} PORT1[1:1] = 0;
        field {} PORT0[0:0] = 0;
    } I2C_BCAST0;

    reg {
        name = "Ports 8 -> 15 Broadcast Control";
        field {} PORT15[7:7] = 0;
        field {} PORT14[6:6] = 0;
        field {} PORT13[5:5] = 0;
        field {} PORT12[4:4] = 0;
        field {} PORT11[3:3] = 0;
        field {} PORT10[2:2] = 0;
        field {} PORT9[1:1] = 0;
        field {} PORT8[0:0] = 0;
    } I2C_BCAST1;

    reg {
        name = "Control bits for I2C communication.";

        field {
            desc = "2'b00 to read, 2'b01 to write, 2'b10 to random-read.";
        } OP[2:1] = 0;

        field {
            desc = "'1' to start next transaction.";
        } START[0:0] = 0;
    } I2C_CTRL;

    reg {
        default sw = r;
        name = "Ports 0 -> 7 I2C core status. '1' is busy.";
        field {} PORT7[7:7] = 0;
        field {} PORT6[6:6] = 0;
        field {} PORT5[5:5] = 0;
        field {} PORT4[4:4] = 0;
        field {} PORT3[3:3] = 0;
        field {} PORT2[2:2] = 0;
        field {} PORT1[1:1] = 0;
        field {} PORT0[0:0] = 0;
    } I2C_BUSY0;

    reg {
        default sw = r;
        name = "Ports 8 -> 15 I2C core status. '1' is busy.";
        field {} PORT15[7:7] = 0;
        field {} PORT14[6:6] = 0;
        field {} PORT13[5:5] = 0;
        field {} PORT12[4:4] = 0;
        field {} PORT11[3:3] = 0;
        field {} PORT10[2:2] = 0;
        field {} PORT9[1:1] = 0;
        field {} PORT8[0:0] = 0;
    } I2C_BUSY1;

    reg port_status {
        default sw = r;

        field {
            desc = "'1' if the module stretched SCL during the last transaction.";
        } STRETCHING_SEEN[7:7] = 0;

        field {
            desc = "'1' if the I2C read data buffer is empty.";
        } RDATA_FIFO_EMPTY[6:6] = 0;

        field {
            desc = "'1' if the I2C write data buffer is empty.";
        } WDATA_FIFO_EMPTY[5:5] = 0;

        field {
            desc = "'1' if the I2C bus is busy.";
        } BUSY[4:4] = 0;

        enum error_types {
            NoError = 4'h0 {desc = "All good!";};
            NoModule = 4'h1 {desc = "No module found (ModPrsL = 1)";};
            NoPower = 4'h2 {desc = "Power not enabled";};
            PowerFault = 4'h3 {desc = "Power good timed out or lost";};
            NotInitialized = 4'h4 {desc = "Module has not been out of reset for duration of t_init";};
            I2cAddressNack = 4'h5 {desc = "Module nack'd the address";};
            I2cByteNack = 4'h6 {desc = "Module nack'd a byte";};
            I2cSclStretchTimeout = 4'h7 {desc = "Module stretched SCL longer than T_clock_hold";};
            I2cTransactionTimeout = 4'h8 {desc = "The transaction did not complete in time and was aborted";};
        };

        field {
            desc = "Port I2C error status";
            encode = error_types;
        } ERROR[3:0] = 0;
    };

    port_status PORT0_STATUS;
    port_status PORT1_STATUS;
    port_status PORT2_STATUS;
    port_status PORT3_STATUS;
    port_status PORT4_STATUS;
    port_status PORT5_STATUS;
    port_status PORT6_STATUS;
    port_status PORT7_STATUS;
    port_status PORT8_STATUS;
    port_status PORT9_STATUS;
    port_status PORT10_STATUS;
    port_status PORT11_STATUS;
    port_status PORT12_STATUS;
    port_status PORT13_STATUS;
    port_status PORT14_STATUS;
    port_status PORT15_STATUS;

    reg port_control {
        field {
            desc ="Setting this bit will clear the I2C read data FIFO. This bit auto-clears.";
        } RDATA_FIFO_CLEAR[2:2] = 0;

        field {
            desc ="Setting this bit will clear the I2C write data FIFO. This bit auto-clears.";
        } WDATA_FIFO_CLEAR[1:1] = 0;

        field {
            desc ="Setting this bit will clear a fault state. Note that if the power supply is not Aborted or TimedOut, nothing will happen. This bit auto-clears.";
        } CLEAR_FAULT[0:0] = 0;
    };

    port_control PORT0_CONTROL;
    port_control PORT1_CONTROL;
    port_control PORT2_CONTROL;
    port_control PORT3_CONTROL;
    port_control PORT4_CONTROL;
    port_control PORT5_CONTROL;
    port_control PORT6_CONTROL;
    port_control PORT7_CONTROL;
    port_control PORT8_CONTROL;
    port_control PORT9_CONTROL;
    port_control PORT10_CONTROL;
    port_control PORT11_CONTROL;
    port_control PORT12_CONTROL;
    port_control PORT13_CONTROL;
    port_control PORT14_CONTROL;
    port_control PORT15_CONTROL;

    reg {
        name = "Ports 0 -> 7 SW control of HSC enable. Clear bit to remove module power.";
        field {} PORT7[7:7] = 1;
        field {} PORT6[6:6] = 1;
        field {} PORT5[5:5] = 1;
        field {} PORT4[4:4] = 1;
        field {} PORT3[3:3] = 1;
        field {} PORT2[2:2] = 1;
        field {} PORT1[1:1] = 1;
        field {} PORT0[0:0] = 1;
    } SW_POWER_EN0;

    reg {
        name = "Ports 8 -> 15 SW control of HSC enable. Clear bit to remove module power.";
        field {} PORT15[7:7] = 1;
        field {} PORT14[6:6] = 1;
        field {} PORT13[5:5] = 1;
        field {} PORT12[4:4] = 1;
        field {} PORT11[3:3] = 1;
        field {} PORT10[2:2] = 1;
        field {} PORT9[1:1] = 1;
        field {} PORT8[0:0] = 1;
    } SW_POWER_EN1;

    reg {
        name = "Ports 0 -> 7 HSC enable pin state. Enabled when the corresponding SW_POWER_EN0 and MODPRSL0 bits are asserted.";
        default sw = r;
        field {} PORT7[7:7] = 1;
        field {} PORT6[6:6] = 1;
        field {} PORT5[5:5] = 1;
        field {} PORT4[4:4] = 1;
        field {} PORT3[3:3] = 1;
        field {} PORT2[2:2] = 1;
        field {} PORT1[1:1] = 1;
        field {} PORT0[0:0] = 1;
    } POWER_EN0;

    reg {
        name = "Ports 8 -> 15 HSC enable pin state. Enabled when the corresponding SW_POWER_EN1 and MODPRSL1 bits are asserted.";
        default sw = r;
        field {} PORT15[7:7] = 1;
        field {} PORT14[6:6] = 1;
        field {} PORT13[5:5] = 1;
        field {} PORT12[4:4] = 1;
        field {} PORT11[3:3] = 1;
        field {} PORT10[2:2] = 1;
        field {} PORT9[1:1] = 1;
        field {} PORT8[0:0] = 1;
    } POWER_EN1;

    reg {
        name = "Ports 0 -> 7 HSC power good";
        default sw = r;
        field {} PORT7[7:7] = 0;
        field {} PORT6[6:6] = 0;
        field {} PORT5[5:5] = 0;
        field {} PORT4[4:4] = 0;
        field {} PORT3[3:3] = 0;
        field {} PORT2[2:2] = 0;
        field {} PORT1[1:1] = 0;
        field {} PORT0[0:0] = 0;
    } POWER_GOOD0;

    reg {
        name = "Ports 8 -> 15 HSC power good";
        default sw = r;
        field {} PORT15[7:7] = 0;
        field {} PORT14[6:6] = 0;
        field {} PORT13[5:5] = 0;
        field {} PORT12[4:4] = 0;
        field {} PORT11[3:3] = 0;
        field {} PORT10[2:2] = 0;
        field {} PORT9[1:1] = 0;
        field {} PORT8[0:0] = 0;
    } POWER_GOOD1;

    reg {
        name = "Ports 0 -> 7 HSC power good not asserted within period after enabled";
        default sw = r;
        field {} PORT7[7:7] = 0;
        field {} PORT6[6:6] = 0;
        field {} PORT5[5:5] = 0;
        field {} PORT4[4:4] = 0;
        field {} PORT3[3:3] = 0;
        field {} PORT2[2:2] = 0;
        field {} PORT1[1:1] = 0;
        field {} PORT0[0:0] = 0;
    } POWER_GOOD_TIMEOUT0;

    reg {
        name = "Ports 8 -> 15 HSC power good not asserted within period after enabled";
        default sw = r;
        field {} PORT15[7:7] = 0;
        field {} PORT14[6:6] = 0;
        field {} PORT13[5:5] = 0;
        field {} PORT12[4:4] = 0;
        field {} PORT11[3:3] = 0;
        field {} PORT10[2:2] = 0;
        field {} PORT9[1:1] = 0;
        field {} PORT8[0:0] = 0;
    } POWER_GOOD_TIMEOUT1;

    reg {
        name = "Ports 0 -> 7 HSC power good lost after successful enable";
        default sw = r;
        field {} PORT7[7:7] = 0;
        field {} PORT6[6:6] = 0;
        field {} PORT5[5:5] = 0;
        field {} PORT4[4:4] = 0;
        field {} PORT3[3:3] = 0;
        field {} PORT2[2:2] = 0;
        field {} PORT1[1:1] = 0;
        field {} PORT0[0:0] = 0;
    } POWER_GOOD_LOST0;

    reg {
        name = "Ports 8 -> 15 HSC power good lost after successful enable";
        default sw = r;
        field {} PORT15[7:7] = 0;
        field {} PORT14[6:6] = 0;
        field {} PORT13[5:5] = 0;
        field {} PORT12[4:4] = 0;
        field {} PORT11[3:3] = 0;
        field {} PORT10[2:2] = 0;
        field {} PORT9[1:1] = 0;
        field {} PORT8[0:0] = 0;
    } POWER_GOOD_LOST1;

    reg {
        name = "Ports 0 -> 7 Module ResetL";
        field {} PORT7[7:7] = 0;
        field {} PORT6[6:6] = 0;
        field {} PORT5[5:5] = 0;
        field {} PORT4[4:4] = 0;
        field {} PORT3[3:3] = 0;
        field {} PORT2[2:2] = 0;
        field {} PORT1[1:1] = 0;
        field {} PORT0[0:0] = 0;
    } MOD_RESETL0;

    reg {
        name = "Ports 8 -> 15 Module ResetL";
        field {} PORT15[7:7] = 0;
        field {} PORT14[6:6] = 0;
        field {} PORT13[5:5] = 0;
        field {} PORT12[4:4] = 0;
        field {} PORT11[3:3] = 0;
        field {} PORT10[2:2] = 0;
        field {} PORT9[1:1] = 0;
        field {} PORT8[0:0] = 0;
    } MOD_RESETL1;

    reg {
        name = "Ports 0 -> 7 Module LPMode/TxDis";
        field {} PORT7[7:7] = 0;
        field {} PORT6[6:6] = 0;
        field {} PORT5[5:5] = 0;
        field {} PORT4[4:4] = 0;
        field {} PORT3[3:3] = 0;
        field {} PORT2[2:2] = 0;
        field {} PORT1[1:1] = 0;
        field {} PORT0[0:0] = 0;
    } MOD_LPMODE0;

    reg {
        name = "Ports 8 -> 15 Module LPMode/TxDis";
        field {} PORT15[7:7] = 0;
        field {} PORT14[6:6] = 0;
        field {} PORT13[5:5] = 0;
        field {} PORT12[4:4] = 0;
        field {} PORT11[3:3] = 0;
        field {} PORT10[2:2] = 0;
        field {} PORT9[1:1] = 0;
        field {} PORT8[0:0] = 0;
    } MOD_LPMODE1;

    reg {
        name = "Ports 0 -> 7 Module ModPrsL";
        default sw = r;
        field {} PORT7[7:7] = 0;
        field {} PORT6[6:6] = 0;
        field {} PORT5[5:5] = 0;
        field {} PORT4[4:4] = 0;
        field {} PORT3[3:3] = 0;
        field {} PORT2[2:2] = 0;
        field {} PORT1[1:1] = 0;
        field {} PORT0[0:0] = 0;
    } MOD_MODPRSL0;

    reg {
        name = "Ports 8 -> 15 Module ModPrsL";
        default sw = r;
        field {} PORT15[7:7] = 0;
        field {} PORT14[6:6] = 0;
        field {} PORT13[5:5] = 0;
        field {} PORT12[4:4] = 0;
        field {} PORT11[3:3] = 0;
        field {} PORT10[2:2] = 0;
        field {} PORT9[1:1] = 0;
        field {} PORT8[0:0] = 0;
    } MOD_MODPRSL1;

    reg {
        name = "Ports 0 -> 7 Module IntL/RxLOS";
        default sw = r;
        field {} PORT7[7:7] = 0;
        field {} PORT6[6:6] = 0;
        field {} PORT5[5:5] = 0;
        field {} PORT4[4:4] = 0;
        field {} PORT3[3:3] = 0;
        field {} PORT2[2:2] = 0;
        field {} PORT1[1:1] = 0;
        field {} PORT0[0:0] = 0;
    } MOD_INTL0;

    reg {
        name = "Ports 8 -> 15 Module IntL/RxLOS";
        default sw = r;
        field {} PORT15[7:7] = 0;
        field {} PORT14[6:6] = 0;
        field {} PORT13[5:5] = 0;
        field {} PORT12[4:4] = 0;
        field {} PORT11[3:3] = 0;
        field {} PORT10[2:2] = 0;
        field {} PORT9[1:1] = 0;
        field {} PORT8[0:0] = 0;
    } MOD_INTL1;

    //
    // I2C Data Buffers
    //

    reg {
        name = "Port 0 I2C data FIFOs. Reading this address pulls from the rdata FIFO, writing it pushes to the wdata FIFO.";
        default sw = r;
        field {} DATA[7:0];
    } PORT0_I2C_DATA @0x0080;

    reg {
        name = "Port 1 I2C data FIFOs. Reading this address pulls from the rdata FIFO, writing it pushes to the wdata FIFO.";
        default sw = r;
        field {} DATA[7:0];
    } PORT1_I2C_DATA;

    reg {
        name = "Port 2 I2C data FIFOs. Reading this address pulls from the rdata FIFO, writing it pushes to the wdata FIFO.";
        default sw = r;
        field {} DATA[7:0];
    } PORT2_I2C_DATA;

    reg {
        name = "Port 3 I2C data FIFOs. Reading this address pulls from the rdata FIFO, writing it pushes to the wdata FIFO.";
        default sw = r;
        field {} DATA[7:0];
    } PORT3_I2C_DATA;

    reg {
        name = "Port 4 I2C data FIFOs. Reading this address pulls from the rdata FIFO, writing it pushes to the wdata FIFO.";
        default sw = r;
        field {} DATA[7:0];
    } PORT4_I2C_DATA;

    reg {
        name = "Port 5 I2C data FIFOs. Reading this address pulls from the rdata FIFO, writing it pushes to the wdata FIFO.";
        default sw = r;
        field {} DATA[7:0];
    } PORT5_I2C_DATA;

    reg {
        name = "Port 6 I2C data FIFOs. Reading this address pulls from the rdata FIFO, writing it pushes to the wdata FIFO.";
        default sw = r;
        field {} DATA[7:0];
    } PORT6_I2C_DATA;

    reg {
        name = "Port 7 I2C data FIFOs. Reading this address pulls from the rdata FIFO, writing it pushes to the wdata FIFO.";
        default sw = r;
        field {} DATA[7:0];
    } PORT7_I2C_DATA;

    reg {
        name = "Port 8 I2C data FIFOs. Reading this address pulls from the rdata FIFO, writing it pushes to the wdata FIFO.";
        default sw = r;
        field {} DATA[7:0];
    } PORT8_I2C_DATA;

    reg {
        name = "Port 9 I2C data FIFOs. Reading this address pulls from the rdata FIFO, writing it pushes to the wdata FIFO.";
        default sw = r;
        field {} DATA[7:0];
    } PORT9_I2C_DATA;

    reg {
        name = "Port 10 I2C data FIFOs. Reading this address pulls from the rdata FIFO, writing it pushes to the wdata FIFO.";
        default sw = r;
        field {} DATA[7:0];
    } PORT10_I2C_DATA;

    reg {
        name = "Port 11 I2C data FIFOs. Reading this address pulls from the rdata FIFO, writing it pushes to the wdata FIFO.";
        default sw = r;
        field {} DATA[7:0];
    } PORT11_I2C_DATA;

    reg {
        name = "Port 12 I2C data FIFOs. Reading this address pulls from the rdata FIFO, writing it pushes to the wdata FIFO.";
        default sw = r;
        field {} DATA[7:0];
    } PORT12_I2C_DATA;

    reg {
        name = "Port 13 I2C data FIFOs. Reading this address pulls from the rdata FIFO, writing it pushes to the wdata FIFO.";
        default sw = r;
        field {} DATA[7:0];
    } PORT13_I2C_DATA;

    reg {
        name = "Port 14 I2C data FIFOs. Reading this address pulls from the rdata FIFO, writing it pushes to the wdata FIFO.";
        default sw = r;
        field {} DATA[7:0];
    } PORT14_I2C_DATA;

    reg {
        name = "Port 15 I2C data FIFOs. Reading this address pulls from the rdata FIFO, writing it pushes to the wdata FIFO.";
        default sw = r;
        field {} DATA[7:0];
    } PORT15_I2C_DATA;

    //
    // Debug Registers
    //

    reg port_debug {
        desc = "Registers primarily for use in testing";

        field {
            desc = "Setting this bit will force an I2C timeout on the current transaction. If one is not in progress, the next one will be aborted. This bit clears itself after a timeout happens.";
        } FORCE_I2C_TIMEOUT[0:0] = 0;
    };

    port_debug PORT0_DEBUG;
    port_debug PORT1_DEBUG;
    port_debug PORT2_DEBUG;
    port_debug PORT3_DEBUG;
    port_debug PORT4_DEBUG;
    port_debug PORT5_DEBUG;
    port_debug PORT6_DEBUG;
    port_debug PORT7_DEBUG;
    port_debug PORT8_DEBUG;
    port_debug PORT9_DEBUG;
    port_debug PORT10_DEBUG;
    port_debug PORT11_DEBUG;
    port_debug PORT12_DEBUG;
    port_debug PORT13_DEBUG;
    port_debug PORT14_DEBUG;
    port_debug PORT15_DEBUG;
};
