//
// This Source Code Form is subject to the terms of the Mozilla Public
// License, v. 2.0. If a copy of the MPL was not distributed with this
// file, You can obtain one at https://mozilla.org/MPL/2.0/.

reg fan_state {
    regwidth = 8;
    default sw = r;
    default hw = w;

    field {
        desc = "FANx_HSC_TO_FPGA_PG was not released within timeout period.";
    } PG_TIMED_OUT[5:5] = 0;
    field {
        desc = "PG was lost during normal operation.";
    } POWER_FAULT[4:4] = 0;
    field {
        desc = "Value of FANx_HSC_TO_FPGA_PG.";
    } PG[3:3] = 0;
    field {
        desc = "Debounced value of FANx_TO_FPGA_PRESENT_2V5.";
    } PRESENT[2:2] = 0;
    field {
        sw = rw;
        hw = r;
        desc = "Drives FPGA_TO_FANx_LED_L (not actually active low).";
    } LED[1:1] = 0;
    field {
        sw = rw;
        hw = rw;
        desc = "Drives FPGA_TO_FANx_HSC_EN. FPGA will clear if FANx_PRESENT not set.";
    } ENABLE[0:0] = 0;
};

addrmap sidecar_mainboard_controller {
    name = "Sidecar Mainboard Controller";
    desc = "Register description of the Sidecar Mainboard Controller";

    default regwidth = 8;
    default sw = rw;
    default hw = r;

    reg {
        name = "Identification 0";
        default sw = r;

        field {
            desc = "Byte 0 of ID";
        } ID0[7:0] = 0x01;
    } ID0;
    reg {
        name = "Identification 1";
        default sw = r;

        field {
            desc = "Byte 1 of ID";
        } ID1[7:0] = 0xde;
    } ID1;
    reg {
        name = "Identification 2";
        default sw = r;

        field {
            desc = "Byte 2 of ID";
        } ID2[7:0] = 0x5b;
    } ID2;
    reg {
        name = "Identification 3";
        default sw = r;

        field {
            desc = "Byte 3 of ID";
        } ID3[7:0] = 0xae;
    } ID3;

    reg {
        name = "Checksum 0";
        field {
            desc = "checksum[31..24]";
        } CS0[7:0] = 0;
    } CS0;
    reg {
        name = "Checksum 1";
        field {
            desc = "checksum[23..16]";
        } CS1[7:0] = 0;
    } CS1;
    reg {
        name = "Checksum 2";
        field {
            desc = "checksum[15..8]";
        } CS2[7:0] = 0;
    } CS2;
    reg {
        name = "Checksum 3";
        field {
            desc = "checksum[7..0]";
        } CS3[7:0] = 0;
    } CS3;

    reg {
        name = "Version 0";
        default sw = r;

        field {
            desc = "version[31..24]";
        } data[7:0] = 0;
    } VERSION0;
    reg {
        name = "Version 1";
        default sw = r;

        field {
            desc = "version[23..16]";
        } data[7:0] = 0;
    } VERSION1;
    reg {
        name = "Version 2";
        default sw = r;

        field {
            desc = "version[15..8]";
        } data[7:0] = 0;
    } VERSION2;
    reg {
        name = "Version 3";
        default sw = r;

        field {
            desc = "version[7..0]";
        } data[7:0] = 0;
    } VERSION3;

    reg {
        name = "Short SHA 0";
        default sw = r;

        field {
            desc = "sha[31..24]";
        } data[7:0] = 0;
    } SHA0;
    reg {
        name = "Short SHA 1";
        default sw = r;

        field {
            desc = "sha[23..16]";
        } data[7:0] = 0;
    } SHA1;
    reg {
        name = "Short SHA 2";
        default sw = r;

        field {
            desc = "sha[15..8]";
        } data[7:0] = 0;
    } SHA2;
    reg {
        name = "Short SHA 3";
        default sw = r;
        field {
            desc = "sha[7..0]";
        } data[7:0] = 0;
    } SHA3;

    reg {
        name = "Scratchpad";

        field {
            desc = "Scribble Register for read-write use";
        } SCRATCHPAD[7:0] = 0;
    } SCRATCHPAD;

    fan_state FAN0_STATE @ 0x20;
    FAN0_STATE->name = "Fan 0 State";

    fan_state FAN1_STATE;
    FAN1_STATE->name = "Fan 1 State";

    fan_state FAN2_STATE;
    FAN2_STATE->name = "Fan 2 State";

    fan_state FAN3_STATE;
    FAN3_STATE->name = "Fan 3 State";

    power_rail_state FRONT_IO_STATE @ 0x30;
    FRONT_IO_STATE->name = "Front IO State";

    reg {
        name = "Tofino Sequencer Control";
        default sw = rw;
        default hw = rw;

        field {
            hw = rw;
            desc = "Set self clearing bit to clear Tofino sequencer error state";
        } CLEAR_ERROR[1] = 0;
        field {
            desc = "Set bit to power up Tofino, clear bit to power down Tofino";
        } EN[1] = 0;
        field {
            hw = rw;
            desc = "Acknowledge that VDDCORE has been adjusted according to the VID";
        } ACK_VID[1] = 0;
    } TOFINO_SEQ_CTRL @ 0x100;

    reg tofino_seq_state {
        name = "Tofino Sequencer State";
        default sw = r;
        default hw = w;

        enum seq_state {
            Init = 3'd0 {desc = "Reset value";};
            A2 = 3'd1 {desc = "Tofino 2 powered off";};
            A0 = 3'd2 {desc = "Tofino 2 powered up";};
            InPowerUp = 3'd3 {desc = "Tofino 2 powering up (transitory state)";};
            InPowerDown = 3'd4 {desc = "Tofino 2 powering off (transitory state)";};
        };

        field {
            desc = "Tofino Sequencer State";
            encode = seq_state;
        } VALUE[2:0] = 0;
    };

    reg tofino_seq_step {
        name = "Tofino Sequencing Step";
        default sw = r;
        default hw = w;

        enum seq_step {
            Init = 4'd0 {desc = "Reset value";};
            AwaitPowerUp = 4'd1 {desc = "Initial step";};
            AwaitVdd18PowerGood = 4'd2 {desc = "Awaiting power good from VDD 1.8V rail";};
            AwaitVddCorePowerGood = 4'd3 {desc = "Awaiting power good from VDD Core rail";};
            AwaitVddPCIePowerGood = 4'd4 {desc = "Awaiting power good from VDD PCIe rail";};
            AwaitVddtPowerGood = 4'd5 {desc = "Awaiting power good from VDDT rail";};
            AwaitVdda15PowerGood = 4'd6 {desc = "Awaiting power good from VDDA 1.5V rail";};
            AwaitVdda18PowerGood = 4'd7 {desc = "Awaiting power good from VDDA 1.8V rail";};
            AwaitPoR = 4'd8 {desc = "Awaiting power on reset";};
            AwaitVidValid = 4'd9 {desc = "Awaiting VID to become valid";};
            AwaitVidAck = 4'd10 {desc = "Awaiting SP to ack VID after adjusting the VRs";};
            AwaitPowerUpComplete = 4'd11 {desc = "Awaiting final power up sequencing delay";};
            AwaitPowerDown = 4'd12 {desc = "Awaiting power down command";};
            AwaitPowerDownComplete = 4'd13 {desc = "Awaiting power down sequencing to complete";};
        };

        field {
            desc = "Sequencing Step";
            encode = seq_step;
        } VALUE[3:0] = 0;
    };

    reg tofino_seq_error {
        name = "Tofino Sequencing Error";
        default sw = r;
        default hw = w;

        enum seq_error {
            None = 3'd0 {desc = "No error";};
            PowerGoodTimeout = 3'd1 {desc = "Power Good ping for a rail was not asserted within the configured timeout.";};
            PowerFault = 3'd2 {desc = "Fault pin for a rail was asserted.";};
            PowerVrHot = 3'd3 {desc = "VR Hot pin was asserted for a rail.";};
            PowerAbort = 3'd4 {desc = "Power Good pin for a rail was deasserted after having been asserted.";};
            SoftwareAbort = 3'd5 {desc = "TOFINO_SEQ_CTRL::EN register was cleared by software.";};
            VidAckTimeout = 3'd6 {desc = "TOFINO_SEQ_CTRL::ACK_VID was not set in time.";};
            ThermalAlert = 3'd7 {desc = "Tofino die temp sensor (U64) asserted the tf_to_fpga_temp_therm_l net.";};
        };

        field {
            desc = "Sequencing Error";
            encode = seq_error;
        } VALUE[2:0] = 0;
    };

    tofino_seq_state TOFINO_SEQ_STATE;
    tofino_seq_step TOFINO_SEQ_STEP;
    tofino_seq_error TOFINO_SEQ_ERROR;

    // When an error does occur, snapshot where it happened
    tofino_seq_state TOFINO_SEQ_ERROR_STATE;
    TOFINO_SEQ_ERROR_STATE->name = "Tofino Sequencer State at Error";
    tofino_seq_step TOFINO_SEQ_ERROR_STEP;
    TOFINO_SEQ_ERROR_STEP->name = "Tofino Sequencer Step at Error";

    power_rail_state TOFINO_POWER_VDD18_STATE;
    TOFINO_POWER_VDD18_STATE->name = "VDD18 State";

    power_rail_state TOFINO_POWER_VDDCORE_STATE;
    TOFINO_POWER_VDDCORE_STATE->name = "VDDCORE State";

    power_rail_state TOFINO_POWER_VDDPCIE_STATE;
    TOFINO_POWER_VDDPCIE_STATE->name = "VDDPCIE State";

    power_rail_state TOFINO_POWER_VDDT_STATE;
    TOFINO_POWER_VDDT_STATE->name = "VDDT State";

    power_rail_state TOFINO_POWER_VDDA15_STATE;
    TOFINO_POWER_VDDA15_STATE->name = "VDDA15 State";

    power_rail_state TOFINO_POWER_VDDA18_STATE;
    TOFINO_POWER_VDDA18_STATE->name = "VDDA18 State";

    reg {
        name = "Tofino VID Value";
        default sw = r;
        default hw = w;

        field {
            desc = "VID Value";
        } VID[4] = 0;
        field {
            desc = "Reserved";
        } RESERVED[3] = 0;
        field {
            desc = "VID Valid";
        } VID_VALID[1] = 0;
    } TOFINO_POWER_VID;

    reg {
        name = "Tofino Reset";
        default sw = r;
        default hw = w;

        field {
            desc = "Tofino package is in reset";
        } PWRON[1] = 0;
        field {
            desc = "Tofino PCIe link is in reset";
        } PCIE[1] = 0;
    } TOFINO_RESET;

    reg {
        name = "Tofino Misc";
        default sw = r;
        default hw = w;

        field {
            desc = "Thermal Alert";
        } THERMAL_ALERT[1] = 0;
        field {
            desc = "Clocks Enable";
        } CLOCKS_EN[1] = 0;
    } TOFINO_MISC;

    reg {
        name = "PCIe Hotplug Control";
        default sw = w;
        default hw = r;

        field {
            desc = "Bit indicating Tofino Present";
        } PRESENT[1] = 0;
        field {
            desc = "Bit indicating the desired state of Tofino PCIe Reset, valid if host override bit set";
        } RESET[1] = 0;
        field {
            desc = "Override host PCIe Reset";
        } OVERRIDE_HOST_RESET[1] = 0;
        field {
            desc = "Bit indicating the desired state of PCIe Power Fault, valid if sequencer override bit set";
        } POWER_FAULT[1] = 0;
        field {
            desc = "Override sequencer power fault";
        } OVERRIDE_SEQ_POWER_FAULT[1] = 0;
    } PCIE_HOTPLUG_CTRL;

    reg {
        name = "PCIe Hotplug Status";
        default sw = r;
        default hw = w;

        field {
            desc = "State of PCIe Present signal";
        } PRESENT[1] = 0;
        field {
            desc = "State of PCIe Reset signal";
        } HOST_RESET[1] = 0;
        field {
            desc = "State of PCIe Power Fault signal";
        } POWER_FAULT[1] = 0;
    } PCIE_HOTPLUG_STATUS;

    reg {
        name = "Tofino Debug Port Data";
        default sw = rw;
        default hw = rw;

        field {
            desc = "Send/receive buffer read/write port";
        } DATA [7:0] = 0;
    } TOFINO_DEBUG_PORT_BUFFER @ 0x200;

    reg {
        name = "Tofino Debug Port Status";
        default sw = r;
        default hw = w;

        field {
            desc = "Send buffer empty";
        } SEND_BUFFER_EMPTY[1] = 0;
        field {
            desc = "Send buffer full";
        } SEND_BUFFER_FULL[1] = 0;
        field {
            desc = "Receive buffer empty";
        } RECEIVE_BUFFER_EMPTY[1] = 0;
        field {
            desc = "Receive buffer full";
        } RECEIVE_BUFFER_FULL[1] = 0;
        field {
            desc = "Flag indicating the port is busy processing requests";
        } REQUEST_IN_PROGRESS[1] = 0;
        field {
            desc = "Flag indicating an I2C error occured";
        } ERROR_VALID[1] = 0;
        field {
            desc = "Field indicating the type of I2C error occured";
        } ERROR_DETAILS[1] = 0;
    } TOFINO_DEBUG_PORT_STATE;

    reg {
        name = "Ignition Controllers Count";

        field {
            desc = "The number of present/active Ignition Controllers";
            sw = r;
            hw = r;
        } COUNT[7:0];
    } IGNITION_CONTROLLERS_COUNT @ 0x300;

    reg {
        name = "Ignition Targets Present 0";
        field {
            desc = "Byte 0 of Ignition Target Present summary";
            sw = r;
            hw = w;
        } PRESENT_SUMMARY0[7:0] = 0;
    } IGNITION_TARGETS_PRESENT0;
    reg {
        name = "Ignition Targets Present 1";
        field {
            desc = "Byte 1 of Ignition Target Present summary";
            sw = r;
            hw = w;
        } PRESENT_SUMMARY1[7:0] = 0;
    } IGNITION_TARGETS_PRESENT1;
    reg {
        name = "Ignition Targets Present 2";
        field {
            desc = "Byte 2 of Ignition Target Present summary";
            sw = r;
            hw = w;
        } PRESENT_SUMMARY2[7:0] = 0;
    } IGNITION_TARGETS_PRESENT2;
    reg {
        name = "Ignition Targets Present 3";
        field {
            desc = "Byte 3 of Ignition Target Present summary";
            sw = r;
            hw = w;
        } PRESENT_SUMMARY3[7:0] = 0;
    } IGNITION_TARGETS_PRESENT3;
    reg {
        name = "Ignition Targets Present 4";
        field {
            desc = "Byte 4 of Ignition Target Present summary";
            sw = r;
            hw = w;
        } PRESENT_SUMMARY4[7:0] = 0;
    } IGNITION_TARGETS_PRESENT4;
    reg {
        name = "Ignition Targets Present 5";
        field {
            desc = "Byte 5 of Ignition Target Present summary";
            sw = r;
            hw = w;
        } PRESENT_SUMMARY5[7:0] = 0;
    } IGNITION_TARGETS_PRESENT5;
    reg {
        name = "Ignition Targets Present 6";
        field {
            desc = "Byte 6 of Ignition Target Present summary";
            sw = r;
            hw = w;
        } PRESENT_SUMMARY6[7:0] = 0;
    } IGNITION_TARGETS_PRESENT6;
    reg {
        name = "Ignition Targets Present 7";
        field {
            desc = "Byte 7 of Ignition Target Present summary";
            sw = r;
            hw = w;
        } PRESENT_SUMMARY7[7:0] = 0;
    } IGNITION_TARGETS_PRESENT7;
};
