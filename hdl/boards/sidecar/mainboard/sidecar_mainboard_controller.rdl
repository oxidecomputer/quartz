// Copyright 2022 Oxide Computer Company
//
// This Source Code Form is subject to the terms of the Mozilla Public
// License, v. 2.0. If a copy of the MPL was not distributed with this
// file, You can obtain one at https://mozilla.org/MPL/2.0/.

addrmap sidecar_mainboard_controller {
    name = "Sidecar Mainboard Controller";
    desc = "Register description of the Sidecar Mainboard Controller";

    default regwidth = 8;
    default sw = rw;
    default hw = r;

    reg {
        name = "Identification 0";
        default sw = r;

        field {
            desc = "Byte 0 of ID";
        } ID0[7:0] = 0x01;
    } ID0;
    reg {
        name = "Identification 1";
        default sw = r;

        field {
            desc = "Byte 1 of ID";
        } ID1[7:0] = 0xde;
    } ID1;
    reg {
        name = "Identification 2";
        default sw = r;

        field {
            desc = "Byte 2 of ID";
        } ID2[7:0] = 0x5b;
    } ID2;
    reg {
        name = "Identification 3";
        default sw = r;

        field {
            desc = "Byte 3 of ID";
        } ID3[7:0] = 0xae;
    } ID3;

    reg {
        name = "Checksum 0";
        field {
            desc = "checksum[31..24]";
        } CS0[7:0] = 0;
    } CS0;
    reg {
        name = "Checksum 1";
        field {
            desc = "checksum[23..16]";
        } CS1[7:0] = 0;
    } CS1;
    reg {
        name = "Checksum 2";
        field {
            desc = "checksum[15..8]";
        } CS2[7:0] = 0;
    } CS2;
    reg {
        name = "Checksum 3";
        field {
            desc = "checksum[7..0]";
        } CS3[7:0] = 0;
    } CS3;

    reg {
        name = "Version 0";
        default sw = r;

        field {
            desc = "version[31..24]";
        } data[7:0] = 0;
    } VERSION0;
    reg {
        name = "Version 1";
        default sw = r;

        field {
            desc = "version[23..16]";
        } data[7:0] = 0;
    } VERSION1;
    reg {
        name = "Version 2";
        default sw = r;

        field {
            desc = "version[15..8]";
        } data[7:0] = 0;
    } VERSION2;
    reg {
        name = "Version 3";
        default sw = r;

        field {
            desc = "version[7..0]";
        } data[7:0] = 0;
    } VERSION3;

    reg {
        name = "Short SHA 0";
        default sw = r;

        field {
            desc = "sha[31..24]";
        } data[7:0] = 0;
    } SHA0;
    reg {
        name = "Short SHA 1";
        default sw = r;

        field {
            desc = "sha[23..16]";
        } data[7:0] = 0;
    } SHA1;
    reg {
        name = "Short SHA 2";
        default sw = r;

        field {
            desc = "sha[15..8]";
        } data[7:0] = 0;
    } SHA2;
    reg {
        name = "Short SHA 3";
        default sw = r;
        field {
            desc = "sha[7..0]";
        } data[7:0] = 0;
    } SHA3;

    reg {
        name = "Scratchpad";

        field {
            desc = "Scribble Register for read-write use";
        } SCRATCHPAD[7:0] = 0;
    } SCRATCHPAD;

    reg {
        name = "Tofino Sequencer Control";
        default sw = rw;
        default hw = rw;

        field {
            hw = rw;
            desc = "Set self clearing bit to clear Tofino sequencer error state";
        } CLEAR_ERROR[1] = 0;
        field {
            desc = "Set bit to power up Tofino, clear bit to power down Tofino";
        } EN[1] = 0;
        field {
            hw = rw;
            desc = "Acknowledge that VDDCORE has been adjusted according to the VID";
        } ACK_VID[1] = 0;
    } TOFINO_SEQ_CTRL @ 0x100;

    reg {
        name = "Tofino Sequencer State";
        default sw = r;
        default hw = w;

        field {
            desc = "Tofino Sequencer State";
        } STATE[2:0] = 0;
    } TOFINO_SEQ_STATE;

    reg {
        name = "Tofino Sequencing Step";
        default sw = r;
        default hw = w;

        field {
            desc = "Sequencing Step";
        } STEP[7:0] = 0;
    } TOFINO_SEQ_STEP;

    reg {
        name = "Tofino Sequencing Error";
        default sw = r;
        default hw = w;

        field {
            desc = "Sequencing Error";
        } ERROR[7:0] = 0;
    } TOFINO_SEQ_ERROR;

    reg {
        name = "Tofino Power Enable";
        default sw = r;
        default hw = w;

        field {
            desc = "VDD 1.8V Enable";
        } VDD_1P8_EN[1] = 0;
        field {
            desc = "VDD Core Enable";
        } VDD_CORE_EN[1] = 0;
        field {
            desc = "VDD 0.75V PCIe Enable";
        } VDD_PCIE_EN[1] = 0;
        field {
            desc = "VDD 0.9V VDDT Enable";
        } VDD_VDDT_EN[1] = 0;
        field {
            desc = "VDDA 1.5V Enable";
        } VDDA_1P5_EN[1] = 0;
        field {
            desc = "VDDA 1.8V Enable";
        } VDDA_1P8_EN[1] = 0;
    } TOFINO_POWER_ENABLE;

    reg {
        name = "Tofino Power Good";
        default sw = r;
        default hw = w;

        field {
            desc = "VDD 1.8V Power Good";
        } VDD_1P8_PG[1] = 0;
        field {
            desc = "VDD Core Power Good";
        } VDD_CORE_PG[1] = 0;
        field {
            desc = "VDD 0.75V PCIe Power Good";
        } VDD_PCIE_PG[1] = 0;
        field {
            desc = "VDD 0.9V VDDT Power Good";
        } VDD_VDDT_PG[1] = 0;
        field {
            desc = "VDDA 1.5V Power Good";
        } VDDA_1P5_PG[1] = 0;
        field {
            desc = "VDDA 1.8V Power Good";
        } VDDA_1P8_PG[1] = 0;
    } TOFINO_POWER_GOOD;

    reg {
        name = "Tofino Power Fault";
        default sw = r;
        default hw = w;

        field {
            desc = "VDD 1.8V Fault";
        } VDD_1P8_FAULT[1] = 0;
        field {
            desc = "VDD Core Fault";
        } VDD_CORE_FAULT[1] = 0;
        field {
            desc = "Reserved";
        } RESERVED1[1] = 0;
        field {
            desc = "VDD 0.9V VDDT Fault";
        } VDD_VDDT_FAULT[1] = 0;
        field {
            desc = "VDDA 1.5V Fault";
        } VDDA_1P5_FAULT[1] = 0;
        field {
            desc = "Reserved";
        } RESERVED2[1] = 0;
    } TOFINO_POWER_FAULT;

    reg {
        name = "Tofino Power VR Hot";
        default sw = r;
        default hw = w;

        field {
            desc = "VDD 1.8V VRHOT";
        } VDD_1P8_VRHOT[1] = 0;
        field {
            desc = "VDD Core VRHOT";
        } VDD_CORE_VRHOT[1] = 0;
        field {
            desc = "Reserved";
        } RESERVED1[1] = 0;
        field {
            desc = "VDD 0.9V VDDT VRHOT";
        } VDD_VDDT_VRHOT[1] = 0;
        field {
            desc = "VDDA 1.5V VRHOT";
        } VDDA_1P5_VRHOT[1] = 0;
        field {
            desc = "VDDA 1.8V VRHOT";
        } VDDA_1P8_VRHOT[1] = 0;
    } TOFINO_POWER_VRHOT;

    reg {
        name = "Tofino VID Value";
        default sw = r;
        default hw = w;

        field {
            desc = "VID Value";
        } VID[4] = 0;
        field {
            desc = "Reserved";
        } RESERVED[3] = 0;
        field {
            desc = "VID Valid";
        } VID_VALID[1] = 0;
    } TOFINO_POWER_VID;

    reg {
        name = "Tofino Reset";
        default sw = r;
        default hw = w;

        field {
            desc = "Tofino package is in reset";
        } PWRON[1] = 0;
        field {
            desc = "PCIe link is in reset";
        } PCIE[1] = 0;
    } TOFINO_RESET;

    reg {
        name = "Tofino Misc";
        default sw = r;
        default hw = w;

        field {
            desc = "Thermal Alert";
        } THERMAL_ALERT[1] = 0;
        field {
            desc = "Clocks Enable";
        } CLOCKS_EN[1] = 0;
    } TOFINO_MISC;

    reg {
        name = "PCIe Hotplug Control";
        default sw = w;
        default hw = r;

        field {
            desc = "Present";
        } PRESENT[1] = 0;
        field {
            desc = "Power Fault";
        } POWER_FAULT[1] = 0;
        field {
            desc = "Alert";
        } ALERT[1] = 0;
        field {
            desc = "PCIe Reset";
        } RESET[1] = 0;
        field {
            desc = "Override host PCIe Reset";
        } OVERRIDE_HOST_RESET[1] = 0;
    } PCIE_HOTPLUG_CTRL;

    reg {
        name = "PCIe Hotplug Status";
        default sw = r;
        default hw = w;

        field {
            desc = "Host PCIe Reset";
        } HOST_RESET[1] = 0;
    } PCIE_HOTPLUG_STATUS;

    reg {
        name = "Tofino Debug Port Data";
        default sw = rw;
        default hw = rw;

        field {
            desc = "Send/receive buffer read/write port";
        } DATA [7:0] = 0;
    } TOFINO_DEBUG_PORT_BUFFER @ 0x200;

    reg {
        name = "Tofino Debug Port Status";
        default sw = r;
        default hw = w;

        field {
            desc = "Send buffer empty";
        } SEND_BUFFER_EMPTY[1] = 0;
        field {
            desc = "Send buffer full";
        } SEND_BUFFER_FULL[1] = 0;
        field {
            desc = "Receive buffer empty";
        } RECEIVE_BUFFER_EMPTY[1] = 0;
        field {
            desc = "Receive buffer full";
        } RECEIVE_BUFFER_FULL[1] = 0;
        field {
            desc = "Flag indicating the port is busy processing requests";
        } REQUEST_IN_PROGRESS[1] = 0;
        field {
            desc = "Flag indicating an I2C error occured";
        } ERROR_VALID[1] = 0;
        field {
            desc = "Field indicating the type of I2C error occured";
        } ERROR_DETAILS[1] = 0;
    } TOFINO_DEBUG_PORT_STATE;
};
