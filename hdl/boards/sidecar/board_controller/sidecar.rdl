// Copyright 2022 Oxide Computer Company
// This is SystemRDL description of the Sidecar ECP5 FPGA

addrmap sidecar_seq {
    name = "Sidecar Board Control FPGA";
    desc = "Register description of the Sidecar Board Control FPGA";

    default regwidth = 8;
    default sw = rw;
    default hw = r;

    reg {
        name = "Identification 0";
        default sw = r;
        
        field {
            desc = "TBD";
        } TBD[7:0] = 0;
    } ID0;
    reg {
        name = "Identification 1";
        default sw = r;
        
        field {
            desc = "TBD";
        } TBD[7:0] = 0;
    } ID1;
    reg {
        name = "Identification 2";
        default sw = r;

        field {
            desc = "TBD";
        } TBD[7:0] = 0;
    } ID2;
    reg {
        name = "Identification 3";
        default sw = r;

        field {
            desc = "TBD";
        } TBD[7:0] = 0;
    } ID3;

    reg {
        name = "Scratchpad";

        field {
            desc = "Scribble Register for read-write use";
        } TBD[7:0] = 0;
    } SCRATCHPAD;

    reg {
        name = "Enable Tofino Power";

        field {
            desc = "0->1 transition = power down sequence, 1->0 transition = power down sequence";
        } EN[1] = 0;
    } TOFINO_EN;

    reg {
        name = "Tofino Sequencer State";
        default sw = r;
        default hw = rw;

        field {
            desc = "sequencer state";
        } STATE[7:0] = 0;
    } TOFINO_SEQ_STATE;

    reg {
        name = "Tofino Sequencer Error";
        default sw = r;
        default hw = rw;

        field {
            desc = "sequencer state";
        } ERROR[7:0] = 0;
    } TOFINO_SEQ_ERROR;

    reg {
        name = "Tofino Power Enables";
        default sw = r;
        default hw = rw;

        field {
            desc = "VDD 1.8V Enable";
        } VDD_1P8_EN[1] = 0;
        field {
            desc = "VDD Core Enable";
        } VDD_CORE_EN[1] = 0;
        field {
            desc = "VDD 0.75V PCIe Enable";
        } VDD_PCIE_EN[1] = 0;
        field {
            desc = "VDD 0.9V VDDT Enable";
        } VDD_VDDT_EN[1] = 0;
        field {
            desc = "VDDA 1.5V Enable";
        } VDDA_1P5_EN[1] = 0;
        field {
            desc = "VDDA 1.8V Enable";
        } VDDA_1P8_EN[1] = 0;
    } TOFINO_POWER_ENABLES;

    reg {
        name = "Tofino Power Goods";
        default sw = r;
        default hw = rw;

        field {
            desc = "VDD 1.8V Power Good";
        } VDD_1P8_PG[1] = 0;
        field {
            desc = "VDD Core Power Good";
        } VDD_CORE_PG[1] = 0;
        field {
            desc = "VDD 0.75V PCIe Power Good";
        } VDD_PCIE_PG[1] = 0;
        field {
            desc = "VDD 0.9V VDDT Power Good";
        } VDD_VDDT_PG[1] = 0;
        field {
            desc = "VDDA 1.5V Power Good";
        } VDDA_1P5_PG[1] = 0;
        field {
            desc = "VDDA 1.8V Power Good";
        } VDDA_1P8_PG[1] = 0;
    } TOFINO_POWER_GOODS;

    reg {
        name = "Tofino VID Bits";
        default sw = r;
        default hw = rw;

        field {
            desc = "VID bits";
        } VID[3:0] = 0;
    } TOFINO_VID;
};